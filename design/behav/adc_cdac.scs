// adc_cdac, behavioral view: one side of the split-capacitor redundant CDAC
// @RNL(type="header") {
//   @VERSION("0.3");
//   @USE-PACKAGE(name="adc28", version="0.1", path="../rnl/adc28.rnl")
// }
// generated by `python -m adcflow gen` from specs/ -- do not edit (specs/arch.yaml, cdac section)
// Uses the deck globals noise_en and tempc.
simulator lang=spectre

subckt adc_cdac (VIN VG TOP VCM VREFP VREFN PHI_S PHI_SB CONV \
        DH12 DH11 DH10 DH9 DH8 DH7 DH6 DH5 DH4 DH3 DH2 DH1 DH0 \
        RL12 RL11 RL10 RL9 RL8 RL7 RL6 RL5 RL4 RL3 RL2 RL1 RL0 DVDD VSS)
parameters cu=5e-16 cp_ratio=0.1 ron_in=25 tau_drv=12p ron_top=20
// input switches (gate VG), tri-state VREFP/VREFN drivers, neutral states
ISW (VIN VG VREFP VREFN CONV \
        DH12 DH11 DH10 DH9 DH8 DH7 DH6 DH5 DH4 DH3 DH2 DH1 DH0 \
        RL12 RL11 RL10 RL9 RL8 RL7 RL6 RL5 RL4 RL3 RL2 RL1 RL0 \
        BH12 BL12 BH11 BL11 BH10 BL10 BH9 BL9 BH8 BL8 BH7 BL7 BH6 \
        BL6 BH5 BL5 BH4 BL4 BH3 BL3 BH2 BL2 BH1 BL1 BH0 BL0 VSS) adc_cdac_sw_va cu=cu ron_in=ron_in tau_drv=tau_drv
// capacitor array: weight w = two halves of w*cu/2 (H: neutral VREFP, L: neutral VREFN)
CH12 (BH12 TOP) capacitor c=512*cu
CL12 (BL12 TOP) capacitor c=512*cu
CH11 (BH11 TOP) capacitor c=256*cu
CL11 (BL11 TOP) capacitor c=256*cu
CH10 (BH10 TOP) capacitor c=128*cu
CL10 (BL10 TOP) capacitor c=128*cu
CH9 (BH9 TOP) capacitor c=96*cu
CL9 (BL9 TOP) capacitor c=96*cu
CH8 (BH8 TOP) capacitor c=64*cu
CL8 (BL8 TOP) capacitor c=64*cu
CH7 (BH7 TOP) capacitor c=32*cu
CL7 (BL7 TOP) capacitor c=32*cu
CH6 (BH6 TOP) capacitor c=16*cu
CL6 (BL6 TOP) capacitor c=16*cu
CH5 (BH5 TOP) capacitor c=16*cu
CL5 (BL5 TOP) capacitor c=16*cu
CH4 (BH4 TOP) capacitor c=8*cu
CL4 (BL4 TOP) capacitor c=8*cu
CH3 (BH3 TOP) capacitor c=4*cu
CL3 (BL3 TOP) capacitor c=4*cu
CH2 (BH2 TOP) capacitor c=2*cu
CL2 (BL2 TOP) capacitor c=2*cu
CH1 (BH1 TOP) capacitor c=1*cu
CL1 (BL1 TOP) capacitor c=1*cu
CH0 (BH0 TOP) capacitor c=0.5*cu
CL0 (BL0 TOP) capacitor c=0.5*cu
// top-plate parasitic: routing, switch junctions, comparator input
CP (TOP VSS) capacitor c=cp_ratio*2271*cu
// top-plate reset switch (PHI_S high = track) in series with the sampled kT/C source
STOP (TOP NK PHI_S VSS) relay vt1=0.35 vt2=0.55 ropen=1e12 rclosed=ron_top
IKTC (NK VCM PHI_S VSS) adc_ktc_va ctot=(1+cp_ratio)*2271*cu tempc=tempc en=noise_en
// @RNL {
//   /* --- semantics --- */
//   &VSS @ADD-TO $GROUND_NET_SET;
//   {#CH12 #CL12 #CH11 #CL11 #CH10 #CL10 #CH9 #CL9 #CH8 #CL8 #CH7 #CL7 #CH6 #CL6 #CH5 #CL5 #CH4 #CL4 #CH3 #CL3 #CH2 #CL2 #CH1 #CL1 #CH0 #CL0} @AS $MATCHED;
//   {#CH12 #CL12} @GROUP;
//   {#CH11 #CL11} @GROUP;
//   {#CH10 #CL10} @GROUP;
//   {#CH9 #CL9} @GROUP;
//   {#CH8 #CL8} @GROUP;
//   {#CH7 #CL7} @GROUP;
//   {#CH6 #CL6} @GROUP;
//   {#CH5 #CL5} @GROUP;
//   {#CH4 #CL4} @GROUP;
//   {#CH3 #CL3} @GROUP;
//   {#CH2 #CL2} @GROUP;
//   {#CH1 #CL1} @GROUP;
//   {#CH0 #CL0} @GROUP;
//   /* --- placement: switch matrix at the bottom, halves above their bottom-plate pins --- */
//   #ISW @PLACE(0, 0);
//   #CH12 @PLACE(0, 11) => @ORIENT("MX");
//   #CL12 @PLACE(3, 11) => @ORIENT("MX");
//   #CH11 @PLACE(6, 11) => @ORIENT("MX");
//   #CL11 @PLACE(9, 11) => @ORIENT("MX");
//   #CH10 @PLACE(12, 11) => @ORIENT("MX");
//   #CL10 @PLACE(15, 11) => @ORIENT("MX");
//   #CH9 @PLACE(18, 11) => @ORIENT("MX");
//   #CL9 @PLACE(21, 11) => @ORIENT("MX");
//   #CH8 @PLACE(24, 11) => @ORIENT("MX");
//   #CL8 @PLACE(27, 11) => @ORIENT("MX");
//   #CH7 @PLACE(30, 11) => @ORIENT("MX");
//   #CL7 @PLACE(33, 11) => @ORIENT("MX");
//   #CH6 @PLACE(36, 11) => @ORIENT("MX");
//   #CL6 @PLACE(39, 11) => @ORIENT("MX");
//   #CH5 @PLACE(42, 11) => @ORIENT("MX");
//   #CL5 @PLACE(45, 11) => @ORIENT("MX");
//   #CH4 @PLACE(48, 11) => @ORIENT("MX");
//   #CL4 @PLACE(51, 11) => @ORIENT("MX");
//   #CH3 @PLACE(54, 11) => @ORIENT("MX");
//   #CL3 @PLACE(57, 11) => @ORIENT("MX");
//   #CH2 @PLACE(60, 11) => @ORIENT("MX");
//   #CL2 @PLACE(63, 11) => @ORIENT("MX");
//   #CH1 @PLACE(66, 11) => @ORIENT("MX");
//   #CL1 @PLACE(69, 11) => @ORIENT("MX");
//   #CH0 @PLACE(72, 11) => @ORIENT("MX");
//   #CL0 @PLACE(75, 11) => @ORIENT("MX");
//   #CP @PLACE(81, 11);
//   #STOP @PLACE(91, 15);
//   #IKTC @PLACE(99, 4);
//   /* --- wires --- */
//   &BH12 @WIRE {#ISW:BH12 #CH12:1};
//   &BL12 @WIRE {#ISW:BL12 #CL12:1};
//   &BH11 @WIRE {#ISW:BH11 #CH11:1};
//   &BL11 @WIRE {#ISW:BL11 #CL11:1};
//   &BH10 @WIRE {#ISW:BH10 #CH10:1};
//   &BL10 @WIRE {#ISW:BL10 #CL10:1};
//   &BH9 @WIRE {#ISW:BH9 #CH9:1};
//   &BL9 @WIRE {#ISW:BL9 #CL9:1};
//   &BH8 @WIRE {#ISW:BH8 #CH8:1};
//   &BL8 @WIRE {#ISW:BL8 #CL8:1};
//   &BH7 @WIRE {#ISW:BH7 #CH7:1};
//   &BL7 @WIRE {#ISW:BL7 #CL7:1};
//   &BH6 @WIRE {#ISW:BH6 #CH6:1};
//   &BL6 @WIRE {#ISW:BL6 #CL6:1};
//   &BH5 @WIRE {#ISW:BH5 #CH5:1};
//   &BL5 @WIRE {#ISW:BL5 #CL5:1};
//   &BH4 @WIRE {#ISW:BH4 #CH4:1};
//   &BL4 @WIRE {#ISW:BL4 #CL4:1};
//   &BH3 @WIRE {#ISW:BH3 #CH3:1};
//   &BL3 @WIRE {#ISW:BL3 #CL3:1};
//   &BH2 @WIRE {#ISW:BH2 #CH2:1};
//   &BL2 @WIRE {#ISW:BL2 #CL2:1};
//   &BH1 @WIRE {#ISW:BH1 #CH1:1};
//   &BL1 @WIRE {#ISW:BL1 #CL1:1};
//   &BH0 @WIRE {#ISW:BH0 #CH0:1};
//   &BL0 @WIRE {#ISW:BL0 #CL0:1};
//   %t0 = (0, 15);
//   &TOP @WIRE {%t0 #CH12:2};
//   %t1 = (3, 15);
//   $JUNCTION @ATTACH %t1;
//   &TOP @WIRE {%t1 #CL12:2};
//   %t2 = (6, 15);
//   $JUNCTION @ATTACH %t2;
//   &TOP @WIRE {%t2 #CH11:2};
//   %t3 = (9, 15);
//   $JUNCTION @ATTACH %t3;
//   &TOP @WIRE {%t3 #CL11:2};
//   %t4 = (12, 15);
//   $JUNCTION @ATTACH %t4;
//   &TOP @WIRE {%t4 #CH10:2};
//   %t5 = (15, 15);
//   $JUNCTION @ATTACH %t5;
//   &TOP @WIRE {%t5 #CL10:2};
//   %t6 = (18, 15);
//   $JUNCTION @ATTACH %t6;
//   &TOP @WIRE {%t6 #CH9:2};
//   %t7 = (21, 15);
//   $JUNCTION @ATTACH %t7;
//   &TOP @WIRE {%t7 #CL9:2};
//   %t8 = (24, 15);
//   $JUNCTION @ATTACH %t8;
//   &TOP @WIRE {%t8 #CH8:2};
//   %t9 = (27, 15);
//   $JUNCTION @ATTACH %t9;
//   &TOP @WIRE {%t9 #CL8:2};
//   %t10 = (30, 15);
//   $JUNCTION @ATTACH %t10;
//   &TOP @WIRE {%t10 #CH7:2};
//   %t11 = (33, 15);
//   $JUNCTION @ATTACH %t11;
//   &TOP @WIRE {%t11 #CL7:2};
//   %t12 = (36, 15);
//   $JUNCTION @ATTACH %t12;
//   &TOP @WIRE {%t12 #CH6:2};
//   %t13 = (39, 15);
//   $JUNCTION @ATTACH %t13;
//   &TOP @WIRE {%t13 #CL6:2};
//   %t14 = (42, 15);
//   $JUNCTION @ATTACH %t14;
//   &TOP @WIRE {%t14 #CH5:2};
//   %t15 = (45, 15);
//   $JUNCTION @ATTACH %t15;
//   &TOP @WIRE {%t15 #CL5:2};
//   %t16 = (48, 15);
//   $JUNCTION @ATTACH %t16;
//   &TOP @WIRE {%t16 #CH4:2};
//   %t17 = (51, 15);
//   $JUNCTION @ATTACH %t17;
//   &TOP @WIRE {%t17 #CL4:2};
//   %t18 = (54, 15);
//   $JUNCTION @ATTACH %t18;
//   &TOP @WIRE {%t18 #CH3:2};
//   %t19 = (57, 15);
//   $JUNCTION @ATTACH %t19;
//   &TOP @WIRE {%t19 #CL3:2};
//   %t20 = (60, 15);
//   $JUNCTION @ATTACH %t20;
//   &TOP @WIRE {%t20 #CH2:2};
//   %t21 = (63, 15);
//   $JUNCTION @ATTACH %t21;
//   &TOP @WIRE {%t21 #CL2:2};
//   %t22 = (66, 15);
//   $JUNCTION @ATTACH %t22;
//   &TOP @WIRE {%t22 #CH1:2};
//   %t23 = (69, 15);
//   $JUNCTION @ATTACH %t23;
//   &TOP @WIRE {%t23 #CL1:2};
//   %t24 = (72, 15);
//   $JUNCTION @ATTACH %t24;
//   &TOP @WIRE {%t24 #CH0:2};
//   %t25 = (75, 15);
//   $JUNCTION @ATTACH %t25;
//   &TOP @WIRE {%t25 #CL0:2};
//   %tcp = (81, 15);
//   $JUNCTION @ATTACH %tcp;
//   %ttop = (84, 15);
//   $JUNCTION @ATTACH %ttop;
//   &TOP @WIRE {%t0 %t1 %t2 %t3 %t4 %t5 %t6 %t7 %t8 %t9 %t10 %t11 %t12 %t13 %t14 %t15 %t16 %t17 %t18 %t19 %t20 %t21 %t22 %t23 %t24 %t25 %tcp %ttop #STOP:1};
//   &TOP @WIRE {%tcp #CP:1};
//   %p_top = $IO_PORT @ATTACH &TOP => @PLACE(84, 19) => @ORIENT("R270");
//   &TOP @WIRE {%p_top:p %ttop};
//   &NK @WIRE {#STOP:2 (99, 15) #IKTC:1};
//   %g_cp = $GROUND @ATTACH &VSS => @PLACE(81, 6);
//   &VSS @WIRE {#CP:2 %g_cp:p};
//   %g_sw = $GROUND @ATTACH &VSS => @PLACE(80, -2);
//   &VSS @WIRE {#ISW:VSS (80, 0) %g_sw:p};
//   %g_st = $GROUND @ATTACH &VSS => @PLACE(93, 10);
//   &VSS @WIRE {#STOP:4 %g_st:p};
//   %g_ktc = $GROUND @ATTACH &VSS => @PLACE(108, 2);
//   &VSS @WIRE {#IKTC:4 (108, 4) %g_ktc:p};
//   %phs = (87, 12);
//   $JUNCTION @ATTACH %phs;
//   %p_phi_s = $IO_PORT @ATTACH &PHI_S => @PLACE(85, 12) => @ORIENT("R0");
//   &PHI_S @WIRE {%p_phi_s:p %phs #STOP:3};
//   &PHI_S @WIRE {%phs (87, 4) #IKTC:3};
//   %p_vcm = $IO_PORT @ATTACH &VCM => @PLACE(99, -4) => @ORIENT("R90");
//   &VCM @WIRE {%p_vcm:p #IKTC:2};
//   %p_vin = $IO_PORT @ATTACH &VIN => @PLACE(-7, 4) => @ORIENT("R0");
//   &VIN @WIRE {%p_vin:p #ISW:VIN};
//   %p_vg = $IO_PORT @ATTACH &VG => @PLACE(-7, 2) => @ORIENT("R0");
//   &VG @WIRE {%p_vg:p #ISW:VG};
//   %p_vrefp = $IO_PORT @ATTACH &VREFP => @PLACE(-7, 0) => @ORIENT("R0");
//   &VREFP @WIRE {%p_vrefp:p #ISW:VREFP};
//   %p_vrefn = $IO_PORT @ATTACH &VREFN => @PLACE(-7, -2) => @ORIENT("R0");
//   &VREFN @WIRE {%p_vrefn:p #ISW:VREFN};
//   %p_conv = $IO_PORT @ATTACH &CONV => @PLACE(-7, -4) => @ORIENT("R0");
//   &CONV @WIRE {%p_conv:p #ISW:CONV};
//   /* PHI_SB and DVDD are not used by the behavioral view */
//   %p_phi_sb = $IO_PORT @ATTACH &PHI_SB => @PLACE(-7, 9) => @ORIENT("R0");
//   %p_dvdd = $IO_PORT @ATTACH &DVDD => @PLACE(-7, 11) => @ORIENT("R0");
//   /* control ports under the switch matrix */
//   %p_dh12 = $IO_PORT @ATTACH &DH12 => @PLACE(0, -10) => @ORIENT("R90");
//   &DH12 @WIRE {%p_dh12:p #ISW:DH12};
//   %p_rl12 = $IO_PORT @ATTACH &RL12 => @PLACE(3, -10) => @ORIENT("R90");
//   &RL12 @WIRE {%p_rl12:p #ISW:RL12};
//   %p_dh11 = $IO_PORT @ATTACH &DH11 => @PLACE(6, -10) => @ORIENT("R90");
//   &DH11 @WIRE {%p_dh11:p #ISW:DH11};
//   %p_rl11 = $IO_PORT @ATTACH &RL11 => @PLACE(9, -10) => @ORIENT("R90");
//   &RL11 @WIRE {%p_rl11:p #ISW:RL11};
//   %p_dh10 = $IO_PORT @ATTACH &DH10 => @PLACE(12, -10) => @ORIENT("R90");
//   &DH10 @WIRE {%p_dh10:p #ISW:DH10};
//   %p_rl10 = $IO_PORT @ATTACH &RL10 => @PLACE(15, -10) => @ORIENT("R90");
//   &RL10 @WIRE {%p_rl10:p #ISW:RL10};
//   %p_dh9 = $IO_PORT @ATTACH &DH9 => @PLACE(18, -10) => @ORIENT("R90");
//   &DH9 @WIRE {%p_dh9:p #ISW:DH9};
//   %p_rl9 = $IO_PORT @ATTACH &RL9 => @PLACE(21, -10) => @ORIENT("R90");
//   &RL9 @WIRE {%p_rl9:p #ISW:RL9};
//   %p_dh8 = $IO_PORT @ATTACH &DH8 => @PLACE(24, -10) => @ORIENT("R90");
//   &DH8 @WIRE {%p_dh8:p #ISW:DH8};
//   %p_rl8 = $IO_PORT @ATTACH &RL8 => @PLACE(27, -10) => @ORIENT("R90");
//   &RL8 @WIRE {%p_rl8:p #ISW:RL8};
//   %p_dh7 = $IO_PORT @ATTACH &DH7 => @PLACE(30, -10) => @ORIENT("R90");
//   &DH7 @WIRE {%p_dh7:p #ISW:DH7};
//   %p_rl7 = $IO_PORT @ATTACH &RL7 => @PLACE(33, -10) => @ORIENT("R90");
//   &RL7 @WIRE {%p_rl7:p #ISW:RL7};
//   %p_dh6 = $IO_PORT @ATTACH &DH6 => @PLACE(36, -10) => @ORIENT("R90");
//   &DH6 @WIRE {%p_dh6:p #ISW:DH6};
//   %p_rl6 = $IO_PORT @ATTACH &RL6 => @PLACE(39, -10) => @ORIENT("R90");
//   &RL6 @WIRE {%p_rl6:p #ISW:RL6};
//   %p_dh5 = $IO_PORT @ATTACH &DH5 => @PLACE(42, -10) => @ORIENT("R90");
//   &DH5 @WIRE {%p_dh5:p #ISW:DH5};
//   %p_rl5 = $IO_PORT @ATTACH &RL5 => @PLACE(45, -10) => @ORIENT("R90");
//   &RL5 @WIRE {%p_rl5:p #ISW:RL5};
//   %p_dh4 = $IO_PORT @ATTACH &DH4 => @PLACE(48, -10) => @ORIENT("R90");
//   &DH4 @WIRE {%p_dh4:p #ISW:DH4};
//   %p_rl4 = $IO_PORT @ATTACH &RL4 => @PLACE(51, -10) => @ORIENT("R90");
//   &RL4 @WIRE {%p_rl4:p #ISW:RL4};
//   %p_dh3 = $IO_PORT @ATTACH &DH3 => @PLACE(54, -10) => @ORIENT("R90");
//   &DH3 @WIRE {%p_dh3:p #ISW:DH3};
//   %p_rl3 = $IO_PORT @ATTACH &RL3 => @PLACE(57, -10) => @ORIENT("R90");
//   &RL3 @WIRE {%p_rl3:p #ISW:RL3};
//   %p_dh2 = $IO_PORT @ATTACH &DH2 => @PLACE(60, -10) => @ORIENT("R90");
//   &DH2 @WIRE {%p_dh2:p #ISW:DH2};
//   %p_rl2 = $IO_PORT @ATTACH &RL2 => @PLACE(63, -10) => @ORIENT("R90");
//   &RL2 @WIRE {%p_rl2:p #ISW:RL2};
//   %p_dh1 = $IO_PORT @ATTACH &DH1 => @PLACE(66, -10) => @ORIENT("R90");
//   &DH1 @WIRE {%p_dh1:p #ISW:DH1};
//   %p_rl1 = $IO_PORT @ATTACH &RL1 => @PLACE(69, -10) => @ORIENT("R90");
//   &RL1 @WIRE {%p_rl1:p #ISW:RL1};
//   %p_dh0 = $IO_PORT @ATTACH &DH0 => @PLACE(72, -10) => @ORIENT("R90");
//   &DH0 @WIRE {%p_dh0:p #ISW:DH0};
//   %p_rl0 = $IO_PORT @ATTACH &RL0 => @PLACE(75, -10) => @ORIENT("R90");
//   &RL0 @WIRE {%p_rl0:p #ISW:RL0};
//   /* --- annotations --- */
//   (1.5, 13.6) @TEXT("w=1024", size=0.6, halign="middle");
//   (7.5, 13.6) @TEXT("w=512", size=0.6, halign="middle");
//   (13.5, 13.6) @TEXT("w=256", size=0.6, halign="middle");
//   (19.5, 13.6) @TEXT("w=192*", size=0.6, halign="middle");
//   (25.5, 13.6) @TEXT("w=128", size=0.6, halign="middle");
//   (31.5, 13.6) @TEXT("w=64", size=0.6, halign="middle");
//   (37.5, 13.6) @TEXT("w=32", size=0.6, halign="middle");
//   (43.5, 13.6) @TEXT("w=32*", size=0.6, halign="middle");
//   (49.5, 13.6) @TEXT("w=16", size=0.6, halign="middle");
//   (55.5, 13.6) @TEXT("w=8", size=0.6, halign="middle");
//   (61.5, 13.6) @TEXT("w=4", size=0.6, halign="middle");
//   (67.5, 13.6) @TEXT("w=2", size=0.6, halign="middle");
//   (73.5, 13.6) @TEXT("w=1", size=0.6, halign="middle");
//   (-7, 24) @TEXT("adc_cdac (behavioral): 13 weights x 2 halves, cu = 0.5 fF, C_S = 1.0235 pF, C_DAC = 1.1355 pF", halign="start") => @SET-STYLE $title_style;
//   (-7, 22) @TEXT("H halves: neutral VREFP, drop on DH; L halves: neutral VREFN, raise on RL; * = not sampled (range extension)", halign="start") => @SET-STYLE $note_style
// }
ends adc_cdac
