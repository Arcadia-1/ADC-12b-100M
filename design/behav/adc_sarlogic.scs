// adc_sarlogic, behavioral view: asynchronous SAR controller
// @RNL(type="header") {
//   @VERSION("0.3");
//   @USE-PACKAGE(name="adc28", version="0.1", path="../rnl/adc28.rnl")
// }
simulator lang=spectre

subckt adc_sarlogic (CONV OUTP OUTN CLKC UP12 UP11 UP10 UP9 UP8 UP7 UP6 UP5 UP4 UP3 UP2 \
        UP1 UP0 DN12 DN11 DN10 DN9 DN8 DN7 DN6 DN5 DN4 DN3 DN2 DN1 DN0 D13 D12 D11 D10 D9 \
        D8 D7 D6 D5 D4 D3 D2 D1 D0 RDY DVDD VSS)
// Behavioral view. Uses the deck global beh_speed.
parameters t_start=100p t_bitd=30p t_rst=35p t_dac_fast=40p t_dac_slow=75p t_timeout=250p \
        t_rdy=140p e_dec=150f
I0 (CONV OUTP OUTN CLKC UP12 UP11 UP10 UP9 UP8 UP7 UP6 UP5 UP4 UP3 UP2 UP1 UP0 DN12 DN11 \
        DN10 DN9 DN8 DN7 DN6 DN5 DN4 DN3 DN2 DN1 DN0 D13 D12 D11 D10 D9 D8 D7 D6 D5 D4 D3 \
        D2 D1 D0 RDY DVDD VSS) adc_sarlogic_va \
        speed=beh_speed t_start=t_start t_bitd=t_bitd t_rst=t_rst t_dac_fast=t_dac_fast \
        t_dac_slow=t_dac_slow t_timeout=t_timeout t_rdy=t_rdy e_dec=e_dec
// @RNL {
//   &DVDD @ADD-TO $SUPPLY_NET_SET;
//   &VSS @ADD-TO $GROUND_NET_SET;
//   #I0 @PLACE(0, 0);
//   %p_conv = $IO_PORT @ATTACH &CONV => @PLACE(-21, 3) => @ORIENT("R0");
//   &CONV @WIRE {%p_conv:p #I0:CONV};
//   %p_outp = $IO_PORT @ATTACH &OUTP => @PLACE(-21, 1) => @ORIENT("R0");
//   &OUTP @WIRE {%p_outp:p #I0:OUTP};
//   %p_outn = $IO_PORT @ATTACH &OUTN => @PLACE(-21, -1) => @ORIENT("R0");
//   &OUTN @WIRE {%p_outn:p #I0:OUTN};
//   %p_clkc = $IO_PORT @ATTACH &CLKC => @PLACE(-21, -3) => @ORIENT("R0");
//   &CLKC @WIRE {%p_clkc:p #I0:CLKC};
//   %p_up12 = $IO_PORT @ATTACH &UP12 => @PLACE(21, 25) => @ORIENT("MY");
//   &UP12 @WIRE {#I0:UP12 %p_up12:p};
//   %p_up11 = $IO_PORT @ATTACH &UP11 => @PLACE(21, 23) => @ORIENT("MY");
//   &UP11 @WIRE {#I0:UP11 %p_up11:p};
//   %p_up10 = $IO_PORT @ATTACH &UP10 => @PLACE(21, 21) => @ORIENT("MY");
//   &UP10 @WIRE {#I0:UP10 %p_up10:p};
//   %p_up9 = $IO_PORT @ATTACH &UP9 => @PLACE(21, 19) => @ORIENT("MY");
//   &UP9 @WIRE {#I0:UP9 %p_up9:p};
//   %p_up8 = $IO_PORT @ATTACH &UP8 => @PLACE(21, 17) => @ORIENT("MY");
//   &UP8 @WIRE {#I0:UP8 %p_up8:p};
//   %p_up7 = $IO_PORT @ATTACH &UP7 => @PLACE(21, 15) => @ORIENT("MY");
//   &UP7 @WIRE {#I0:UP7 %p_up7:p};
//   %p_up6 = $IO_PORT @ATTACH &UP6 => @PLACE(21, 13) => @ORIENT("MY");
//   &UP6 @WIRE {#I0:UP6 %p_up6:p};
//   %p_up5 = $IO_PORT @ATTACH &UP5 => @PLACE(21, 11) => @ORIENT("MY");
//   &UP5 @WIRE {#I0:UP5 %p_up5:p};
//   %p_up4 = $IO_PORT @ATTACH &UP4 => @PLACE(21, 9) => @ORIENT("MY");
//   &UP4 @WIRE {#I0:UP4 %p_up4:p};
//   %p_up3 = $IO_PORT @ATTACH &UP3 => @PLACE(21, 7) => @ORIENT("MY");
//   &UP3 @WIRE {#I0:UP3 %p_up3:p};
//   %p_up2 = $IO_PORT @ATTACH &UP2 => @PLACE(21, 5) => @ORIENT("MY");
//   &UP2 @WIRE {#I0:UP2 %p_up2:p};
//   %p_up1 = $IO_PORT @ATTACH &UP1 => @PLACE(21, 3) => @ORIENT("MY");
//   &UP1 @WIRE {#I0:UP1 %p_up1:p};
//   %p_up0 = $IO_PORT @ATTACH &UP0 => @PLACE(21, 1) => @ORIENT("MY");
//   &UP0 @WIRE {#I0:UP0 %p_up0:p};
//   %p_dn12 = $IO_PORT @ATTACH &DN12 => @PLACE(21, -1) => @ORIENT("MY");
//   &DN12 @WIRE {#I0:DN12 %p_dn12:p};
//   %p_dn11 = $IO_PORT @ATTACH &DN11 => @PLACE(21, -3) => @ORIENT("MY");
//   &DN11 @WIRE {#I0:DN11 %p_dn11:p};
//   %p_dn10 = $IO_PORT @ATTACH &DN10 => @PLACE(21, -5) => @ORIENT("MY");
//   &DN10 @WIRE {#I0:DN10 %p_dn10:p};
//   %p_dn9 = $IO_PORT @ATTACH &DN9 => @PLACE(21, -7) => @ORIENT("MY");
//   &DN9 @WIRE {#I0:DN9 %p_dn9:p};
//   %p_dn8 = $IO_PORT @ATTACH &DN8 => @PLACE(21, -9) => @ORIENT("MY");
//   &DN8 @WIRE {#I0:DN8 %p_dn8:p};
//   %p_dn7 = $IO_PORT @ATTACH &DN7 => @PLACE(21, -11) => @ORIENT("MY");
//   &DN7 @WIRE {#I0:DN7 %p_dn7:p};
//   %p_dn6 = $IO_PORT @ATTACH &DN6 => @PLACE(21, -13) => @ORIENT("MY");
//   &DN6 @WIRE {#I0:DN6 %p_dn6:p};
//   %p_dn5 = $IO_PORT @ATTACH &DN5 => @PLACE(21, -15) => @ORIENT("MY");
//   &DN5 @WIRE {#I0:DN5 %p_dn5:p};
//   %p_dn4 = $IO_PORT @ATTACH &DN4 => @PLACE(21, -17) => @ORIENT("MY");
//   &DN4 @WIRE {#I0:DN4 %p_dn4:p};
//   %p_dn3 = $IO_PORT @ATTACH &DN3 => @PLACE(21, -19) => @ORIENT("MY");
//   &DN3 @WIRE {#I0:DN3 %p_dn3:p};
//   %p_dn2 = $IO_PORT @ATTACH &DN2 => @PLACE(21, -21) => @ORIENT("MY");
//   &DN2 @WIRE {#I0:DN2 %p_dn2:p};
//   %p_dn1 = $IO_PORT @ATTACH &DN1 => @PLACE(21, -23) => @ORIENT("MY");
//   &DN1 @WIRE {#I0:DN1 %p_dn1:p};
//   %p_dn0 = $IO_PORT @ATTACH &DN0 => @PLACE(21, -25) => @ORIENT("MY");
//   &DN0 @WIRE {#I0:DN0 %p_dn0:p};
//   %p_d13 = $IO_PORT @ATTACH &D13 => @PLACE(-14, -32) => @ORIENT("R90");
//   &D13 @WIRE {%p_d13:p #I0:D13};
//   %p_d12 = $IO_PORT @ATTACH &D12 => @PLACE(-12, -32) => @ORIENT("R90");
//   &D12 @WIRE {%p_d12:p #I0:D12};
//   %p_d11 = $IO_PORT @ATTACH &D11 => @PLACE(-10, -32) => @ORIENT("R90");
//   &D11 @WIRE {%p_d11:p #I0:D11};
//   %p_d10 = $IO_PORT @ATTACH &D10 => @PLACE(-8, -32) => @ORIENT("R90");
//   &D10 @WIRE {%p_d10:p #I0:D10};
//   %p_d9 = $IO_PORT @ATTACH &D9 => @PLACE(-6, -32) => @ORIENT("R90");
//   &D9 @WIRE {%p_d9:p #I0:D9};
//   %p_d8 = $IO_PORT @ATTACH &D8 => @PLACE(-4, -32) => @ORIENT("R90");
//   &D8 @WIRE {%p_d8:p #I0:D8};
//   %p_d7 = $IO_PORT @ATTACH &D7 => @PLACE(-2, -32) => @ORIENT("R90");
//   &D7 @WIRE {%p_d7:p #I0:D7};
//   %p_d6 = $IO_PORT @ATTACH &D6 => @PLACE(0, -32) => @ORIENT("R90");
//   &D6 @WIRE {%p_d6:p #I0:D6};
//   %p_d5 = $IO_PORT @ATTACH &D5 => @PLACE(2, -32) => @ORIENT("R90");
//   &D5 @WIRE {%p_d5:p #I0:D5};
//   %p_d4 = $IO_PORT @ATTACH &D4 => @PLACE(4, -32) => @ORIENT("R90");
//   &D4 @WIRE {%p_d4:p #I0:D4};
//   %p_d3 = $IO_PORT @ATTACH &D3 => @PLACE(6, -32) => @ORIENT("R90");
//   &D3 @WIRE {%p_d3:p #I0:D3};
//   %p_d2 = $IO_PORT @ATTACH &D2 => @PLACE(8, -32) => @ORIENT("R90");
//   &D2 @WIRE {%p_d2:p #I0:D2};
//   %p_d1 = $IO_PORT @ATTACH &D1 => @PLACE(10, -32) => @ORIENT("R90");
//   &D1 @WIRE {%p_d1:p #I0:D1};
//   %p_d0 = $IO_PORT @ATTACH &D0 => @PLACE(12, -32) => @ORIENT("R90");
//   &D0 @WIRE {%p_d0:p #I0:D0};
//   %p_rdy = $IO_PORT @ATTACH &RDY => @PLACE(14, -32) => @ORIENT("R90");
//   &RDY @WIRE {%p_rdy:p #I0:RDY};
//   %s1 = $SUPPLY @ATTACH &DVDD => @PLACE(-1, 30);
//   &DVDD @WIRE {#I0:DVDD %s1:p};
//   %g1 = $GROUND @ATTACH &VSS => @PLACE(5, 30);
//   &VSS @WIRE {#I0:VSS (1, 30) (5, 30) %g1:p};
//   (-22, 36) @TEXT("adc_sarlogic (behavioral): asynchronous SAR controller, bit and output registers", halign="start") => @SET-STYLE $title_style;
//   (-22, 34.5) @TEXT("decision k -> UP/DN<13-k>, D<14-k>; DAC wait 40 ps (steps 1-6) / 75 ps; timeout 250 ps forces 1; all delays scaled by beh_speed", halign="start") => @SET-STYLE $note_style
// }
ends adc_sarlogic
