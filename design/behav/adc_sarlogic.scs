// adc_sarlogic, behavioral view: asynchronous SAR controller
// @RNL(type="header") {
//   @VERSION("0.3");
//   @USE-PACKAGE(name="adc28", version="0.1", path="../rnl/adc28.rnl")
// }
simulator lang=spectre

subckt adc_sarlogic (CONV OUTP OUTN CLKC UP12 UP11 UP10 UP9 UP8 UP7 UP6 UP5 UP4 UP3 UP2 \
        UP1 UP0 DN12 DN11 DN10 DN9 DN8 DN7 DN6 DN5 DN4 DN3 DN2 DN1 DN0 D13 D12 D11 D10 D9 \
        D8 D7 D6 D5 D4 D3 D2 D1 D0 RDY DVDD VSS)
// Behavioral view. Uses the deck global beh_speed.
parameters t_start=100p t_bitd=30p t_rst=35p t_dac_fast=40p t_dac_slow=75p t_timeout=250p \
        t_rdy=140p e_dec=150f
I0 (CONV OUTP OUTN CLKC UP12 UP11 UP10 UP9 UP8 UP7 UP6 UP5 UP4 UP3 UP2 UP1 UP0 DN12 DN11 \
        DN10 DN9 DN8 DN7 DN6 DN5 DN4 DN3 DN2 DN1 DN0 D13 D12 D11 D10 D9 D8 D7 D6 D5 D4 D3 \
        D2 D1 D0 RDY DVDD VSS) adc_sarlogic_va \
        speed=beh_speed t_start=t_start t_bitd=t_bitd t_rst=t_rst t_dac_fast=t_dac_fast \
        t_dac_slow=t_dac_slow t_timeout=t_timeout t_rdy=t_rdy e_dec=e_dec
// @RNL {
//   /* --- semantics --- */
//   &DVDD @ADD-TO $SUPPLY_NET_SET;
//   &VSS @ADD-TO $GROUND_NET_SET;
//   /* --- placement and wires: the buses UP, DN and D leave as one bus port each --- */
//   #I0 @PLACE(0, 0);
//   %p_conv = $IO_PORT @ATTACH &CONV => @PLACE(-11, 5) => @ORIENT("R0");
//   &CONV @WIRE {%p_conv:p #I0:CONV};
//   %p_outp = $IO_PORT @ATTACH &OUTP => @PLACE(-11, 1) => @ORIENT("R0");
//   &OUTP @WIRE {%p_outp:p #I0:OUTP};
//   %p_outn = $IO_PORT @ATTACH &OUTN => @PLACE(-11, -1) => @ORIENT("R0");
//   &OUTN @WIRE {%p_outn:p #I0:OUTN};
//   %p_clkc = $IO_PORT @ATTACH &CLKC => @PLACE(-11, -5) => @ORIENT("R0");
//   &CLKC @WIRE {%p_clkc:p #I0:CLKC};
//   %p_up = (13, 3)(p) {&UP12 &UP11 &UP10 &UP9 &UP8 &UP7 &UP6 &UP5 &UP4 &UP3 &UP2 &UP1 &UP0}(nets) @AS $BUS_PORT => @ORIENT("MY");
//   %p_up @TEXT("UP<12:0>", key="name");
//   %bus_up = {&UP12 &UP11 &UP10 &UP9 &UP8 &UP7 &UP6 &UP5 &UP4 &UP3 &UP2 &UP1 &UP0} @WIRE {#I0:UP12 %p_up:p};
//   %p_dn = (13, -3)(p) {&DN12 &DN11 &DN10 &DN9 &DN8 &DN7 &DN6 &DN5 &DN4 &DN3 &DN2 &DN1 &DN0}(nets) @AS $BUS_PORT => @ORIENT("MY");
//   %p_dn @TEXT("DN<12:0>", key="name");
//   %bus_dn = {&DN12 &DN11 &DN10 &DN9 &DN8 &DN7 &DN6 &DN5 &DN4 &DN3 &DN2 &DN1 &DN0} @WIRE {#I0:DN12 %p_dn:p};
//   %p_d = (-2, -13)(p) {&D13 &D12 &D11 &D10 &D9 &D8 &D7 &D6 &D5 &D4 &D3 &D2 &D1 &D0}(nets) @AS $BUS_PORT => @ORIENT("R90");
//   %p_d @TEXT("D<13:0>", key="name");
//   %bus_d = {&D13 &D12 &D11 &D10 &D9 &D8 &D7 &D6 &D5 &D4 &D3 &D2 &D1 &D0} @WIRE {#I0:D13 %p_d:p};
//   %p_rdy = $IO_PORT @ATTACH &RDY => @PLACE(2, -12) => @ORIENT("R90");
//   &RDY @WIRE {#I0:RDY %p_rdy:p};
//   %g1 = $GROUND @ATTACH &VSS => @PLACE(5, -10);
//   &VSS @WIRE {#I0:VSS %g1:p};
//   %s1 = $SUPPLY @ATTACH &DVDD => @PLACE(0, 10);
//   &DVDD @WIRE {#I0:DVDD %s1:p};
//   /* --- annotations --- */
//   (-12, 16) @TEXT("adc_sarlogic (behavioral): asynchronous SAR controller, bit and output registers", halign="start") => @SET-STYLE $title_style;
//   (-12, 14.5) @TEXT("decision k -> UP/DN<13-k>, D<14-k>; DAC wait 40 ps (steps 1-6) / 75 ps; timeout 250 ps forces 1; all delays scaled by beh_speed", halign="start") => @SET-STYLE $note_style
// }
ends adc_sarlogic
