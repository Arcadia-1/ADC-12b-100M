// Behavioral dynamic comparator for adc_comp (behav view).
// CLKC low: OUTP = OUTN = 0 (after trst). CLKC rising: the differential input
// plus offset and Gaussian noise is sampled; after t0 + tau*ln(vsat/|vd|)
// (clipped to [t0, tmax]) OUTP (vd > 0) or OUTN rises. A falling CLKC
// cancels a pending decision. Energy per comparison is drawn from AVDD.
`include "disciplines.vams"
`include "constants.vams"

module adc_comp_va(INP, INN, CLKC, OUTP, OUTN, AVDD, VSS);
  input INP, INN, CLKC;
  output OUTP, OUTN;
  inout AVDD, VSS;
  electrical INP, INN, CLKC, OUTP, OUTN, AVDD, VSS;

  parameter real sigma = 80e-6 from [0:inf);   // input-referred noise, V rms (diff)
  parameter real vos = 0.0;                     // input offset, V
  parameter real t0 = 45e-12 from (0:inf);      // delay for |vd| >= vsat
  parameter real tau = 8e-12 from (0:inf);      // regeneration time constant
  parameter real vsat = 30e-3 from (0:inf);
  parameter real tmax = 1e-9 from (0:inf);      // metastable decisions give up after tmax
  parameter real trst = 25e-12 from (0:inf);    // CLKC fall -> outputs low
  parameter real tr = 8e-12 from (0:inf);       // output edges
  parameter real energy = 120e-15 from [0:inf); // J per comparison
  parameter real tw = 40e-12 from (0:inf);      // supply current pulse width
  parameter integer seed0 = 11;

  integer seed, pending, dec, outp, outn;
  real vd, td, t_out, t_rst, t_iend, ipulse;

  analog begin
    @(initial_step) begin
      seed = seed0; pending = 0; dec = 0; outp = 0; outn = 0;
      t_out = 1e9; t_rst = 1e9; t_iend = 1e9; ipulse = 0;
    end

    @(cross(V(CLKC, VSS) - 0.5 * V(AVDD, VSS), +1)) begin
      vd = V(INP, INN) - vos + sigma * $rdist_normal(seed, 0.0, 1.0);
      dec = (vd > 0) ? 1 : 0;
      if (abs(vd) >= vsat) td = t0;
      else if (abs(vd) < 1e-15) td = tmax;
      else td = t0 + tau * ln(vsat / abs(vd));
      if (td > tmax) td = tmax;
      t_out = $abstime + td;
      pending = 1;
      t_rst = 1e9;
      ipulse = energy / (max(V(AVDD, VSS), 0.1) * tw);
      t_iend = $abstime + tw;
    end

    @(timer(t_out)) begin
      if (pending) begin
        outp = dec; outn = 1 - dec; pending = 0;
      end
      t_out = 1e9;
    end

    @(cross(V(CLKC, VSS) - 0.5 * V(AVDD, VSS), -1)) begin
      pending = 0; t_out = 1e9;
      t_rst = $abstime + trst;
    end

    @(timer(t_rst)) begin
      outp = 0; outn = 0; t_rst = 1e9;
    end

    @(timer(t_iend)) begin
      ipulse = 0; t_iend = 1e9;
    end

    V(OUTP, VSS) <+ transition(outp, 0, tr) * V(AVDD, VSS);
    V(OUTN, VSS) <+ transition(outn, 0, tr) * V(AVDD, VSS);
    I(AVDD, VSS) <+ transition(ipulse, 0, 5e-12);
  end
endmodule
