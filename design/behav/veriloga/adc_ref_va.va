// Behavioral reference driver for adc_ref (behav view).
// VREFP is pulled toward VREF_IN through an output conductance 1/rout with
// a single-pole loop (bandwidth fbw); the sourced current comes from AVDD18,
// the sunk current goes to VSS. VCM = vcm_ratio * VREFP through rcm (sourced
// from AVDD). The decoupling capacitors are separate elements of adc_ref.
`include "disciplines.vams"
`include "constants.vams"

module adc_ref_va(VREF_IN, VREFP, VCM, AVDD18, AVDD, VSS);
  input VREF_IN;
  output VREFP, VCM;
  inout AVDD18, AVDD, VSS;
  electrical VREF_IN, VREFP, VCM, AVDD18, AVDD, VSS;

  parameter real rout = 1.0 from (0:inf);      // DC output resistance of VREFP
  parameter real fbw = 50e6 from (0:inf);      // loop bandwidth of the correction
  parameter real vcm_ratio = 0.5;
  parameter real rcm = 500 from (0:inf);
  parameter real iq18 = 150e-6 from [0:inf);   // quiescent AVDD18 current
  parameter real iq09 = 5e-6 from [0:inf);     // quiescent AVDD current
  parameter real vos = 0.0;                    // output offset

  real verr, iout, icm;

  analog begin
    // error filtered by the loop bandwidth, converted to an output current
    verr = laplace_nd(V(VREF_IN, VSS) + vos - V(VREFP, VSS), {1}, {1, 1 / (2 * `M_PI * fbw)});
    iout = verr / rout;                       // > 0: sourcing into VREFP
    icm = (vcm_ratio * V(VREFP, VSS) - V(VCM, VSS)) / rcm;
    I(AVDD18, VREFP) <+ max(iout, 0);
    I(VREFP, VSS) <+ max(-iout, 0);
    I(AVDD, VCM) <+ max(icm, 0);
    I(VCM, VSS) <+ max(-icm, 0);
    I(AVDD18, VSS) <+ iq18;
    I(AVDD, VSS) <+ iq09;
  end
endmodule
