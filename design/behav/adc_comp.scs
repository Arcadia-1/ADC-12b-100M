// adc_comp, behavioral view: dynamic latched comparator
// @RNL(type="header") {
//   @VERSION("0.3");
//   @USE-PACKAGE(name="adc28", version="0.1", path="../rnl/adc28.rnl")
// }
simulator lang=spectre

subckt adc_comp (INP INN CLKC OUTP OUTN AVDD VSS)
// Behavioral view. Uses the deck globals noise_en and beh_speed.
parameters sigma=80u vos=0 t0=45p tau=8p vsat=30m trst=25p energy=120f cin=10f
I0 (INP INN CLKC OUTP OUTN AVDD VSS) adc_comp_va \
        sigma=sigma*noise_en vos=vos t0=t0*beh_speed tau=tau*beh_speed vsat=vsat trst=trst*beh_speed energy=energy
CINP (INP VSS) capacitor c=cin
CINN (INN VSS) capacitor c=cin
// @RNL {
//   /* --- semantics --- */
//   &AVDD @ADD-TO $SUPPLY_NET_SET;
//   &VSS @ADD-TO $GROUND_NET_SET;
//   {#CINP #CINN} @AS $MATCHED;
//   /* --- placement --- */
//   #I0 @PLACE(0, 0);
//   #CINP @PLACE(-16, -1);
//   #CINN @PLACE(-10, -3);
//   /* --- wires --- */
//   %jinp = (-16, 1);
//   $JUNCTION @ATTACH %jinp;
//   %jinn = (-10, -1);
//   $JUNCTION @ATTACH %jinn;
//   %p_inp = $IO_PORT @ATTACH &INP => @PLACE(-20, 1) => @ORIENT("R0");
//   &INP @WIRE {%p_inp:p %jinp #I0:INP};
//   &INP @WIRE {%jinp #CINP:1};
//   %p_inn = $IO_PORT @ATTACH &INN => @PLACE(-13, -1) => @ORIENT("R0");
//   &INN @WIRE {%p_inn:p %jinn #I0:INN};
//   &INN @WIRE {%jinn #CINN:1};
//   %g1 = $GROUND @ATTACH &VSS => @PLACE(-16, -4);
//   &VSS @WIRE {#CINP:2 %g1:p};
//   %g2 = $GROUND @ATTACH &VSS => @PLACE(-10, -6);
//   &VSS @WIRE {#CINN:2 %g2:p};
//   %p_clkc = $IO_PORT @ATTACH &CLKC => @PLACE(-2, -8) => @ORIENT("R90");
//   &CLKC @WIRE {%p_clkc:p #I0:CLKC};
//   %g3 = $GROUND @ATTACH &VSS => @PLACE(2, -6);
//   &VSS @WIRE {#I0:VSS %g3:p};
//   %s1 = $SUPPLY @ATTACH &AVDD => @PLACE(0, 6);
//   &AVDD @WIRE {#I0:AVDD %s1:p};
//   %p_outp = $IO_PORT @ATTACH &OUTP => @PLACE(11, 1) => @ORIENT("MY");
//   &OUTP @WIRE {#I0:OUTP %p_outp:p};
//   %p_outn = $IO_PORT @ATTACH &OUTN => @PLACE(11, -1) => @ORIENT("MY");
//   &OUTN @WIRE {#I0:OUTN %p_outn:p};
//   /* --- annotations --- */
//   (-20, 11) @TEXT("adc_comp (behavioral): latched comparator, delay t0 + tau*ln(vsat/|vd|)", halign="start") => @SET-STYLE $title_style;
//   (-20, 9.5) @TEXT("noise sigma*noise_en (Gaussian per decision), timing scaled by beh_speed; CIN models the input capacitance", halign="start") => @SET-STYLE $note_style
// }
ends adc_comp
