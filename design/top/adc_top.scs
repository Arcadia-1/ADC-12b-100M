// adc_top: 12-bit-class 100 MS/s asynchronous SAR ADC, structural top level
// @RNL(type="header") {
//   @VERSION("0.3");
//   @USE-PACKAGE(name="adc28", version="0.1", path="../rnl/adc28.rnl")
// }
// generated by `python -m adcflow gen` from specs/ -- do not edit (tools/adcflow/gen_top.py)
// The same file is used with any mix of block views (behav / xtor).
simulator lang=spectre

subckt adc_top (VINP VINN CLK VREF_IN \
        D13 D12 D11 D10 D9 D8 D7 D6 D5 D4 D3 D2 D1 D0 RDY \
        AVDD DVDD AVDD18 VSS)
// reference driver and sampling phases
XREF (VREF_IN VREFP VCM AVDD18 AVDD VSS) adc_ref
XCLK (CLK PHI_S PHI_SB PHI_B PHI_BB CONV AVDD VSS) adc_clkgen
// bottom-plate sampling front end (P side: DH = DN, RL = UP; N side: DH = UP, RL = DN)
XBSP (VINP PHI_B PHI_BB VGP AVDD VSS) adc_bootstrap
XBSN (VINN PHI_B PHI_BB VGN AVDD VSS) adc_bootstrap
XDACP (VINP VGP TOPP VCM VREFP VSS PHI_S PHI_SB CONV DN12 DN11 DN10 DN9 DN8 DN7 DN6 DN5 DN4 \
        DN3 DN2 DN1 DN0 UP12 UP11 UP10 UP9 UP8 UP7 UP6 UP5 UP4 UP3 UP2 UP1 UP0 DVDD VSS) adc_cdac
XDACN (VINN VGN TOPN VCM VREFP VSS PHI_S PHI_SB CONV UP12 UP11 UP10 UP9 UP8 UP7 UP6 UP5 UP4 \
        UP3 UP2 UP1 UP0 DN12 DN11 DN10 DN9 DN8 DN7 DN6 DN5 DN4 DN3 DN2 DN1 DN0 DVDD VSS) adc_cdac
// comparator: INP <- TOPN, INN <- TOPP (the top plates are inverted), OUTP = 1 means UP
XCMP (TOPN TOPP CLKC OUTP OUTN AVDD VSS) adc_comp
XLOG (CONV OUTP OUTN CLKC UP12 UP11 UP10 UP9 UP8 UP7 UP6 UP5 UP4 UP3 UP2 UP1 UP0 DN12 DN11 \
        DN10 DN9 DN8 DN7 DN6 DN5 DN4 DN3 DN2 DN1 DN0 D13 D12 D11 D10 D9 D8 D7 D6 D5 D4 D3 D2 \
        D1 D0 RDY DVDD VSS) adc_sarlogic
// @RNL {
//   /* --- semantics --- */
//   {&AVDD &DVDD &AVDD18} @ADD-TO $SUPPLY_NET_SET;
//   &VSS @ADD-TO $GROUND_NET_SET;
//   {#XDACP #XDACN} @AS $MATCHED;
//   {#XBSP #XBSN} @AS $MATCHED;
//   {#XBSP #XDACP #XCMP #XLOG} @AS(direction="left-to-right") $FLOW;
//   {#XBSN #XDACN} @AS(direction="left-to-right") $FLOW;
//   {#XBSP #XDACP} @GROUP;
//   {#XBSN #XDACN} @GROUP;
//   /* --- placement --- */
//   #XREF @PLACE(-17, 56);
//   #XBSP @PLACE(-17, 32);
//   #XDACP @PLACE(25, 30);
//   #XBSN @PLACE(-17, -8);
//   #XDACN @PLACE(25, -10);
//   #XCMP @PLACE(72, 10);
//   #XLOG @PLACE(112, 10);
//   #XCLK @PLACE(-17, -42);
//   /* --- inputs and sampling front end --- */
//   %jvinp = (-28, 38);
//   $JUNCTION @ATTACH %jvinp;
//   %p_vinp = $IO_PORT @ATTACH &VINP => @PLACE(-44, 38) => @ORIENT("R0");
//   &VINP @WIRE {%p_vinp:p %jvinp (-7, 38) (-7, 34) #XDACP:VIN};
//   &VINP @WIRE {%jvinp (-28, 34) #XBSP:VIN};
//   &VGP @WIRE {#XBSP:VG #XDACP:VG};
//   %jvinn = (-28, -2);
//   $JUNCTION @ATTACH %jvinn;
//   %p_vinn = $IO_PORT @ATTACH &VINN => @PLACE(-44, -2) => @ORIENT("R0");
//   &VINN @WIRE {%p_vinn:p %jvinn (-7, -2) (-7, -6) #XDACN:VIN};
//   &VINN @WIRE {%jvinn (-28, -6) #XBSN:VIN};
//   &VGN @WIRE {#XBSN:VG #XDACN:VG};
//   /* --- top plates to the comparator (crossed: INP <- TOPN) --- */
//   &TOPP @WIRE {#XDACP:TOP (61, 30) (61, 9) #XCMP:INN};
//   &TOPN @WIRE {#XDACN:TOP (63, -10) (63, 11) #XCMP:INP};
//   /* --- comparator <-> SAR logic --- */
//   &OUTP @WIRE {#XCMP:OUTP #XLOG:OUTP};
//   &OUTN @WIRE {#XCMP:OUTN #XLOG:OUTN};
//   &CLKC @WIRE {#XLOG:CLKC (89, 7) (89, 3) (70, 3) #XCMP:CLKC};
//   /* --- clock and reference inputs --- */
//   %p_clk = $IO_PORT @ATTACH &CLK => @PLACE(-30, -42) => @ORIENT("R0");
//   &CLK @WIRE {%p_clk:p #XCLK:CLK};
//   %p_vref_in = $IO_PORT @ATTACH &VREF_IN => @PLACE(-30, 56) => @ORIENT("R0");
//   &VREF_IN @WIRE {%p_vref_in:p #XREF:VREF_IN};
//   /* --- outputs: raw bits and RDY below the SAR logic --- */
//   %p_d13 = $IO_PORT @ATTACH &D13 => @PLACE(98, -22) => @ORIENT("R90");
//   &D13 @WIRE {%p_d13:p #XLOG:D13};
//   %p_d12 = $IO_PORT @ATTACH &D12 => @PLACE(100, -22) => @ORIENT("R90");
//   &D12 @WIRE {%p_d12:p #XLOG:D12};
//   %p_d11 = $IO_PORT @ATTACH &D11 => @PLACE(102, -22) => @ORIENT("R90");
//   &D11 @WIRE {%p_d11:p #XLOG:D11};
//   %p_d10 = $IO_PORT @ATTACH &D10 => @PLACE(104, -22) => @ORIENT("R90");
//   &D10 @WIRE {%p_d10:p #XLOG:D10};
//   %p_d9 = $IO_PORT @ATTACH &D9 => @PLACE(106, -22) => @ORIENT("R90");
//   &D9 @WIRE {%p_d9:p #XLOG:D9};
//   %p_d8 = $IO_PORT @ATTACH &D8 => @PLACE(108, -22) => @ORIENT("R90");
//   &D8 @WIRE {%p_d8:p #XLOG:D8};
//   %p_d7 = $IO_PORT @ATTACH &D7 => @PLACE(110, -22) => @ORIENT("R90");
//   &D7 @WIRE {%p_d7:p #XLOG:D7};
//   %p_d6 = $IO_PORT @ATTACH &D6 => @PLACE(112, -22) => @ORIENT("R90");
//   &D6 @WIRE {%p_d6:p #XLOG:D6};
//   %p_d5 = $IO_PORT @ATTACH &D5 => @PLACE(114, -22) => @ORIENT("R90");
//   &D5 @WIRE {%p_d5:p #XLOG:D5};
//   %p_d4 = $IO_PORT @ATTACH &D4 => @PLACE(116, -22) => @ORIENT("R90");
//   &D4 @WIRE {%p_d4:p #XLOG:D4};
//   %p_d3 = $IO_PORT @ATTACH &D3 => @PLACE(118, -22) => @ORIENT("R90");
//   &D3 @WIRE {%p_d3:p #XLOG:D3};
//   %p_d2 = $IO_PORT @ATTACH &D2 => @PLACE(120, -22) => @ORIENT("R90");
//   &D2 @WIRE {%p_d2:p #XLOG:D2};
//   %p_d1 = $IO_PORT @ATTACH &D1 => @PLACE(122, -22) => @ORIENT("R90");
//   &D1 @WIRE {%p_d1:p #XLOG:D1};
//   %p_d0 = $IO_PORT @ATTACH &D0 => @PLACE(124, -22) => @ORIENT("R90");
//   &D0 @WIRE {%p_d0:p #XLOG:D0};
//   %p_rdy = $IO_PORT @ATTACH &RDY => @PLACE(126, -22) => @ORIENT("R90");
//   &RDY @WIRE {%p_rdy:p #XLOG:RDY};
//   /* --- supplies and grounds --- */
//   %s1 = $SUPPLY @ATTACH &AVDD18 => @PLACE(-19, 62);
//   &AVDD18 @WIRE {#XREF:AVDD18 %s1:p};
//   %s2 = $SUPPLY @ATTACH &AVDD => @PLACE(-15, 62);
//   &AVDD @WIRE {#XREF:AVDD %s2:p};
//   %g3 = $GROUND @ATTACH &VSS => @PLACE(-17, 50);
//   &VSS @WIRE {#XREF:VSS %g3:p};
//   %s4 = $SUPPLY @ATTACH &AVDD => @PLACE(-17, -33);
//   &AVDD @WIRE {#XCLK:AVDD %s4:p};
//   %g5 = $GROUND @ATTACH &VSS => @PLACE(-17, -51);
//   &VSS @WIRE {#XCLK:VSS %g5:p};
//   %s6 = $SUPPLY @ATTACH &AVDD => @PLACE(-17, 39);
//   &AVDD @WIRE {#XBSP:AVDD %s6:p};
//   %g7 = $GROUND @ATTACH &VSS => @PLACE(-17, 25);
//   &VSS @WIRE {#XBSP:VSS %g7:p};
//   %s8 = $SUPPLY @ATTACH &AVDD => @PLACE(-17, -1);
//   &AVDD @WIRE {#XBSN:AVDD %s8:p};
//   %g9 = $GROUND @ATTACH &VSS => @PLACE(-17, -15);
//   &VSS @WIRE {#XBSN:VSS %g9:p};
//   %g10 = $GROUND @ATTACH &VSS => @PLACE(-2, 21);
//   &VSS @WIRE {#XDACP:VREFN %g10:p};
//   %s11 = $SUPPLY @ATTACH &DVDD => @PLACE(27, 39);
//   &DVDD @WIRE {#XDACP:DVDD %s11:p};
//   %g12 = $GROUND @ATTACH &VSS => @PLACE(52, 21);
//   &VSS @WIRE {#XDACP:VSS %g12:p};
//   %g13 = $GROUND @ATTACH &VSS => @PLACE(-2, -19);
//   &VSS @WIRE {#XDACN:VREFN %g13:p};
//   %s14 = $SUPPLY @ATTACH &DVDD => @PLACE(27, -1);
//   &DVDD @WIRE {#XDACN:DVDD %s14:p};
//   %g15 = $GROUND @ATTACH &VSS => @PLACE(52, -19);
//   &VSS @WIRE {#XDACN:VSS %g15:p};
//   %s16 = $SUPPLY @ATTACH &AVDD => @PLACE(72, 16);
//   &AVDD @WIRE {#XCMP:AVDD %s16:p};
//   %g17 = $GROUND @ATTACH &VSS => @PLACE(74, 4);
//   &VSS @WIRE {#XCMP:VSS %g17:p};
//   %s18 = $SUPPLY @ATTACH &DVDD => @PLACE(111, 40);
//   &DVDD @WIRE {#XLOG:DVDD %s18:p};
//   %g19 = $GROUND @ATTACH &VSS => @PLACE(116, 39);
//   &VSS @WIRE {#XLOG:VSS (113, 40) (116, 40) %g19:p};
//   /* --- pins connected by net name (phases, references, UP/DN buses) --- */
//   &VREFP @WIRE {#XREF:VREFP (-8, 57)};
//   (-7.7, 56.75) @TEXT("VREFP", size=0.6, halign="start");
//   &VCM @WIRE {#XREF:VCM (-8, 55)};
//   (-7.7, 54.75) @TEXT("VCM", size=0.6, halign="start");
//   &PHI_S @WIRE {#XCLK:PHI_S (-8, -38)};
//   (-7.7, -38.25) @TEXT("PHI_S", size=0.6, halign="start");
//   &PHI_SB @WIRE {#XCLK:PHI_SB (-8, -40)};
//   (-7.7, -40.25) @TEXT("PHI_SB", size=0.6, halign="start");
//   &PHI_B @WIRE {#XCLK:PHI_B (-8, -42)};
//   (-7.7, -42.25) @TEXT("PHI_B", size=0.6, halign="start");
//   &PHI_BB @WIRE {#XCLK:PHI_BB (-8, -44)};
//   (-7.7, -44.25) @TEXT("PHI_BB", size=0.6, halign="start");
//   &CONV @WIRE {#XCLK:CONV (-8, -46)};
//   (-7.7, -46.25) @TEXT("CONV", size=0.6, halign="start");
//   &PHI_B @WIRE {#XBSP:PHI_B (-26, 32)};
//   (-26.3, 31.75) @TEXT("PHI_B", size=0.6, halign="end");
//   &PHI_BB @WIRE {#XBSP:PHI_BB (-26, 30)};
//   (-26.3, 29.75) @TEXT("PHI_BB", size=0.6, halign="end");
//   &PHI_B @WIRE {#XBSN:PHI_B (-26, -8)};
//   (-26.3, -8.25) @TEXT("PHI_B", size=0.6, halign="end");
//   &PHI_BB @WIRE {#XBSN:PHI_BB (-26, -10)};
//   (-26.3, -10.25) @TEXT("PHI_BB", size=0.6, halign="end");
//   &VCM @WIRE {#XDACP:VCM (23, 39)};
//   (23.25, 39.3) @TEXT("VCM", size=0.6, rotate=90, halign="start");
//   &VREFP @WIRE {#XDACP:VREFP (25, 39)};
//   (25.25, 39.3) @TEXT("VREFP", size=0.6, rotate=90, halign="start");
//   &PHI_S @WIRE {#XDACP:PHI_S (-7, 30)};
//   (-7.3, 29.75) @TEXT("PHI_S", size=0.6, halign="end");
//   &PHI_SB @WIRE {#XDACP:PHI_SB (-7, 28)};
//   (-7.3, 27.75) @TEXT("PHI_SB", size=0.6, halign="end");
//   &CONV @WIRE {#XDACP:CONV (-7, 26)};
//   (-7.3, 25.75) @TEXT("CONV", size=0.6, halign="end");
//   &DN12 @WIRE {#XDACP:DH12 (0, 21)};
//   (0.25, 20.7) @TEXT("DN12", size=0.6, rotate=90, halign="end");
//   &DN11 @WIRE {#XDACP:DH11 (2, 21)};
//   (2.25, 20.7) @TEXT("DN11", size=0.6, rotate=90, halign="end");
//   &DN10 @WIRE {#XDACP:DH10 (4, 21)};
//   (4.25, 20.7) @TEXT("DN10", size=0.6, rotate=90, halign="end");
//   &DN9 @WIRE {#XDACP:DH9 (6, 21)};
//   (6.25, 20.7) @TEXT("DN9", size=0.6, rotate=90, halign="end");
//   &DN8 @WIRE {#XDACP:DH8 (8, 21)};
//   (8.25, 20.7) @TEXT("DN8", size=0.6, rotate=90, halign="end");
//   &DN7 @WIRE {#XDACP:DH7 (10, 21)};
//   (10.25, 20.7) @TEXT("DN7", size=0.6, rotate=90, halign="end");
//   &DN6 @WIRE {#XDACP:DH6 (12, 21)};
//   (12.25, 20.7) @TEXT("DN6", size=0.6, rotate=90, halign="end");
//   &DN5 @WIRE {#XDACP:DH5 (14, 21)};
//   (14.25, 20.7) @TEXT("DN5", size=0.6, rotate=90, halign="end");
//   &DN4 @WIRE {#XDACP:DH4 (16, 21)};
//   (16.25, 20.7) @TEXT("DN4", size=0.6, rotate=90, halign="end");
//   &DN3 @WIRE {#XDACP:DH3 (18, 21)};
//   (18.25, 20.7) @TEXT("DN3", size=0.6, rotate=90, halign="end");
//   &DN2 @WIRE {#XDACP:DH2 (20, 21)};
//   (20.25, 20.7) @TEXT("DN2", size=0.6, rotate=90, halign="end");
//   &DN1 @WIRE {#XDACP:DH1 (22, 21)};
//   (22.25, 20.7) @TEXT("DN1", size=0.6, rotate=90, halign="end");
//   &DN0 @WIRE {#XDACP:DH0 (24, 21)};
//   (24.25, 20.7) @TEXT("DN0", size=0.6, rotate=90, halign="end");
//   &UP12 @WIRE {#XDACP:RL12 (26, 21)};
//   (26.25, 20.7) @TEXT("UP12", size=0.6, rotate=90, halign="end");
//   &UP11 @WIRE {#XDACP:RL11 (28, 21)};
//   (28.25, 20.7) @TEXT("UP11", size=0.6, rotate=90, halign="end");
//   &UP10 @WIRE {#XDACP:RL10 (30, 21)};
//   (30.25, 20.7) @TEXT("UP10", size=0.6, rotate=90, halign="end");
//   &UP9 @WIRE {#XDACP:RL9 (32, 21)};
//   (32.25, 20.7) @TEXT("UP9", size=0.6, rotate=90, halign="end");
//   &UP8 @WIRE {#XDACP:RL8 (34, 21)};
//   (34.25, 20.7) @TEXT("UP8", size=0.6, rotate=90, halign="end");
//   &UP7 @WIRE {#XDACP:RL7 (36, 21)};
//   (36.25, 20.7) @TEXT("UP7", size=0.6, rotate=90, halign="end");
//   &UP6 @WIRE {#XDACP:RL6 (38, 21)};
//   (38.25, 20.7) @TEXT("UP6", size=0.6, rotate=90, halign="end");
//   &UP5 @WIRE {#XDACP:RL5 (40, 21)};
//   (40.25, 20.7) @TEXT("UP5", size=0.6, rotate=90, halign="end");
//   &UP4 @WIRE {#XDACP:RL4 (42, 21)};
//   (42.25, 20.7) @TEXT("UP4", size=0.6, rotate=90, halign="end");
//   &UP3 @WIRE {#XDACP:RL3 (44, 21)};
//   (44.25, 20.7) @TEXT("UP3", size=0.6, rotate=90, halign="end");
//   &UP2 @WIRE {#XDACP:RL2 (46, 21)};
//   (46.25, 20.7) @TEXT("UP2", size=0.6, rotate=90, halign="end");
//   &UP1 @WIRE {#XDACP:RL1 (48, 21)};
//   (48.25, 20.7) @TEXT("UP1", size=0.6, rotate=90, halign="end");
//   &UP0 @WIRE {#XDACP:RL0 (50, 21)};
//   (50.25, 20.7) @TEXT("UP0", size=0.6, rotate=90, halign="end");
//   &VCM @WIRE {#XDACN:VCM (23, -1)};
//   (23.25, -0.7) @TEXT("VCM", size=0.6, rotate=90, halign="start");
//   &VREFP @WIRE {#XDACN:VREFP (25, -1)};
//   (25.25, -0.7) @TEXT("VREFP", size=0.6, rotate=90, halign="start");
//   &PHI_S @WIRE {#XDACN:PHI_S (-7, -10)};
//   (-7.3, -10.25) @TEXT("PHI_S", size=0.6, halign="end");
//   &PHI_SB @WIRE {#XDACN:PHI_SB (-7, -12)};
//   (-7.3, -12.25) @TEXT("PHI_SB", size=0.6, halign="end");
//   &CONV @WIRE {#XDACN:CONV (-7, -14)};
//   (-7.3, -14.25) @TEXT("CONV", size=0.6, halign="end");
//   &UP12 @WIRE {#XDACN:DH12 (0, -19)};
//   (0.25, -19.3) @TEXT("UP12", size=0.6, rotate=90, halign="end");
//   &UP11 @WIRE {#XDACN:DH11 (2, -19)};
//   (2.25, -19.3) @TEXT("UP11", size=0.6, rotate=90, halign="end");
//   &UP10 @WIRE {#XDACN:DH10 (4, -19)};
//   (4.25, -19.3) @TEXT("UP10", size=0.6, rotate=90, halign="end");
//   &UP9 @WIRE {#XDACN:DH9 (6, -19)};
//   (6.25, -19.3) @TEXT("UP9", size=0.6, rotate=90, halign="end");
//   &UP8 @WIRE {#XDACN:DH8 (8, -19)};
//   (8.25, -19.3) @TEXT("UP8", size=0.6, rotate=90, halign="end");
//   &UP7 @WIRE {#XDACN:DH7 (10, -19)};
//   (10.25, -19.3) @TEXT("UP7", size=0.6, rotate=90, halign="end");
//   &UP6 @WIRE {#XDACN:DH6 (12, -19)};
//   (12.25, -19.3) @TEXT("UP6", size=0.6, rotate=90, halign="end");
//   &UP5 @WIRE {#XDACN:DH5 (14, -19)};
//   (14.25, -19.3) @TEXT("UP5", size=0.6, rotate=90, halign="end");
//   &UP4 @WIRE {#XDACN:DH4 (16, -19)};
//   (16.25, -19.3) @TEXT("UP4", size=0.6, rotate=90, halign="end");
//   &UP3 @WIRE {#XDACN:DH3 (18, -19)};
//   (18.25, -19.3) @TEXT("UP3", size=0.6, rotate=90, halign="end");
//   &UP2 @WIRE {#XDACN:DH2 (20, -19)};
//   (20.25, -19.3) @TEXT("UP2", size=0.6, rotate=90, halign="end");
//   &UP1 @WIRE {#XDACN:DH1 (22, -19)};
//   (22.25, -19.3) @TEXT("UP1", size=0.6, rotate=90, halign="end");
//   &UP0 @WIRE {#XDACN:DH0 (24, -19)};
//   (24.25, -19.3) @TEXT("UP0", size=0.6, rotate=90, halign="end");
//   &DN12 @WIRE {#XDACN:RL12 (26, -19)};
//   (26.25, -19.3) @TEXT("DN12", size=0.6, rotate=90, halign="end");
//   &DN11 @WIRE {#XDACN:RL11 (28, -19)};
//   (28.25, -19.3) @TEXT("DN11", size=0.6, rotate=90, halign="end");
//   &DN10 @WIRE {#XDACN:RL10 (30, -19)};
//   (30.25, -19.3) @TEXT("DN10", size=0.6, rotate=90, halign="end");
//   &DN9 @WIRE {#XDACN:RL9 (32, -19)};
//   (32.25, -19.3) @TEXT("DN9", size=0.6, rotate=90, halign="end");
//   &DN8 @WIRE {#XDACN:RL8 (34, -19)};
//   (34.25, -19.3) @TEXT("DN8", size=0.6, rotate=90, halign="end");
//   &DN7 @WIRE {#XDACN:RL7 (36, -19)};
//   (36.25, -19.3) @TEXT("DN7", size=0.6, rotate=90, halign="end");
//   &DN6 @WIRE {#XDACN:RL6 (38, -19)};
//   (38.25, -19.3) @TEXT("DN6", size=0.6, rotate=90, halign="end");
//   &DN5 @WIRE {#XDACN:RL5 (40, -19)};
//   (40.25, -19.3) @TEXT("DN5", size=0.6, rotate=90, halign="end");
//   &DN4 @WIRE {#XDACN:RL4 (42, -19)};
//   (42.25, -19.3) @TEXT("DN4", size=0.6, rotate=90, halign="end");
//   &DN3 @WIRE {#XDACN:RL3 (44, -19)};
//   (44.25, -19.3) @TEXT("DN3", size=0.6, rotate=90, halign="end");
//   &DN2 @WIRE {#XDACN:RL2 (46, -19)};
//   (46.25, -19.3) @TEXT("DN2", size=0.6, rotate=90, halign="end");
//   &DN1 @WIRE {#XDACN:RL1 (48, -19)};
//   (48.25, -19.3) @TEXT("DN1", size=0.6, rotate=90, halign="end");
//   &DN0 @WIRE {#XDACN:RL0 (50, -19)};
//   (50.25, -19.3) @TEXT("DN0", size=0.6, rotate=90, halign="end");
//   &CONV @WIRE {#XLOG:CONV (93, 13)};
//   (92.7, 12.75) @TEXT("CONV", size=0.6, halign="end");
//   &UP12 @WIRE {#XLOG:UP12 (131, 35)};
//   (131.3, 34.75) @TEXT("UP12", size=0.6, halign="start");
//   &UP11 @WIRE {#XLOG:UP11 (131, 33)};
//   (131.3, 32.75) @TEXT("UP11", size=0.6, halign="start");
//   &UP10 @WIRE {#XLOG:UP10 (131, 31)};
//   (131.3, 30.75) @TEXT("UP10", size=0.6, halign="start");
//   &UP9 @WIRE {#XLOG:UP9 (131, 29)};
//   (131.3, 28.75) @TEXT("UP9", size=0.6, halign="start");
//   &UP8 @WIRE {#XLOG:UP8 (131, 27)};
//   (131.3, 26.75) @TEXT("UP8", size=0.6, halign="start");
//   &UP7 @WIRE {#XLOG:UP7 (131, 25)};
//   (131.3, 24.75) @TEXT("UP7", size=0.6, halign="start");
//   &UP6 @WIRE {#XLOG:UP6 (131, 23)};
//   (131.3, 22.75) @TEXT("UP6", size=0.6, halign="start");
//   &UP5 @WIRE {#XLOG:UP5 (131, 21)};
//   (131.3, 20.75) @TEXT("UP5", size=0.6, halign="start");
//   &UP4 @WIRE {#XLOG:UP4 (131, 19)};
//   (131.3, 18.75) @TEXT("UP4", size=0.6, halign="start");
//   &UP3 @WIRE {#XLOG:UP3 (131, 17)};
//   (131.3, 16.75) @TEXT("UP3", size=0.6, halign="start");
//   &UP2 @WIRE {#XLOG:UP2 (131, 15)};
//   (131.3, 14.75) @TEXT("UP2", size=0.6, halign="start");
//   &UP1 @WIRE {#XLOG:UP1 (131, 13)};
//   (131.3, 12.75) @TEXT("UP1", size=0.6, halign="start");
//   &UP0 @WIRE {#XLOG:UP0 (131, 11)};
//   (131.3, 10.75) @TEXT("UP0", size=0.6, halign="start");
//   &DN12 @WIRE {#XLOG:DN12 (131, 9)};
//   (131.3, 8.75) @TEXT("DN12", size=0.6, halign="start");
//   &DN11 @WIRE {#XLOG:DN11 (131, 7)};
//   (131.3, 6.75) @TEXT("DN11", size=0.6, halign="start");
//   &DN10 @WIRE {#XLOG:DN10 (131, 5)};
//   (131.3, 4.75) @TEXT("DN10", size=0.6, halign="start");
//   &DN9 @WIRE {#XLOG:DN9 (131, 3)};
//   (131.3, 2.75) @TEXT("DN9", size=0.6, halign="start");
//   &DN8 @WIRE {#XLOG:DN8 (131, 1)};
//   (131.3, 0.75) @TEXT("DN8", size=0.6, halign="start");
//   &DN7 @WIRE {#XLOG:DN7 (131, -1)};
//   (131.3, -1.25) @TEXT("DN7", size=0.6, halign="start");
//   &DN6 @WIRE {#XLOG:DN6 (131, -3)};
//   (131.3, -3.25) @TEXT("DN6", size=0.6, halign="start");
//   &DN5 @WIRE {#XLOG:DN5 (131, -5)};
//   (131.3, -5.25) @TEXT("DN5", size=0.6, halign="start");
//   &DN4 @WIRE {#XLOG:DN4 (131, -7)};
//   (131.3, -7.25) @TEXT("DN4", size=0.6, halign="start");
//   &DN3 @WIRE {#XLOG:DN3 (131, -9)};
//   (131.3, -9.25) @TEXT("DN3", size=0.6, halign="start");
//   &DN2 @WIRE {#XLOG:DN2 (131, -11)};
//   (131.3, -11.25) @TEXT("DN2", size=0.6, halign="start");
//   &DN1 @WIRE {#XLOG:DN1 (131, -13)};
//   (131.3, -13.25) @TEXT("DN1", size=0.6, halign="start");
//   &DN0 @WIRE {#XLOG:DN0 (131, -15)};
//   (131.3, -15.25) @TEXT("DN0", size=0.6, halign="start");
//   /* --- annotations --- */
//   (-44, 68) @TEXT("adc_top: 100 MS/s asynchronous SAR, bottom-plate sampling, split-capacitor redundant CDAC", halign="start") => @SET-STYLE $title_style;
//   (-44, 66) @TEXT("14 decisions, raw bits D13..D0 with weights 2048 1024 512 384 256 128 64 64 32 16 8 4 2 1; code = sum(W*D); unwired pins are connected by net name", halign="start") => @SET-STYLE $note_style;
//   (25, 12.5) @TEXT("P side: DH<j> = DN<j>, RL<j> = UP<j>", halign="middle") => @SET-STYLE $note_style;
//   (25, -27.5) @TEXT("N side: DH<j> = UP<j>, RL<j> = DN<j>", halign="middle") => @SET-STYLE $note_style;
//   (72, 20) @TEXT("INP <- TOPN, INN <- TOPP: OUTP = 1 means input above DAC level", halign="middle") => @SET-STYLE $note_style
// }
ends adc_top
