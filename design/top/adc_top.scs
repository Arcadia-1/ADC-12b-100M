// adc_top: 12-bit-class 100 MS/s asynchronous SAR ADC, structural top level
// @RNL(type="header") {
//   @VERSION("0.3");
//   @USE-PACKAGE(name="adc28", version="0.1", path="../rnl/adc28.rnl")
// }
// generated by `python -m adcflow gen` from specs/ -- do not edit (tools/adcflow/gen_top.py)
// The same file is used with any mix of block views (behav / xtor).
simulator lang=spectre

subckt adc_top (VINP VINN CLK VREF_IN \
        D13 D12 D11 D10 D9 D8 D7 D6 D5 D4 D3 D2 D1 D0 RDY \
        AVDD DVDD AVDD18 VSS)
// reference driver and sampling phases
XREF (VREF_IN VREFP VCM AVDD18 AVDD VSS) adc_ref
XCLK (CLK PHI_S PHI_SB PHI_B PHI_BB CONV AVDD VSS) adc_clkgen
// bottom-plate sampling front end (P side: DH = DN, RL = UP; N side: DH = UP, RL = DN)
XBSP (VINP PHI_B PHI_BB VGP AVDD VSS) adc_bootstrap
XBSN (VINN PHI_B PHI_BB VGN AVDD VSS) adc_bootstrap
XDACP (VINP VGP TOPP VCM VREFP VSS PHI_S PHI_SB CONV DN12 DN11 DN10 DN9 DN8 DN7 DN6 DN5 DN4 \
        DN3 DN2 DN1 DN0 UP12 UP11 UP10 UP9 UP8 UP7 UP6 UP5 UP4 UP3 UP2 UP1 UP0 DVDD VSS) adc_cdac
XDACN (VINN VGN TOPN VCM VREFP VSS PHI_S PHI_SB CONV UP12 UP11 UP10 UP9 UP8 UP7 UP6 UP5 UP4 \
        UP3 UP2 UP1 UP0 DN12 DN11 DN10 DN9 DN8 DN7 DN6 DN5 DN4 DN3 DN2 DN1 DN0 DVDD VSS) adc_cdac
// comparator: INP <- TOPN, INN <- TOPP (the top plates are inverted), OUTP = 1 means UP
XCMP (TOPN TOPP CLKC OUTP OUTN AVDD VSS) adc_comp
XLOG (CONV OUTP OUTN CLKC UP12 UP11 UP10 UP9 UP8 UP7 UP6 UP5 UP4 UP3 UP2 UP1 UP0 DN12 DN11 \
        DN10 DN9 DN8 DN7 DN6 DN5 DN4 DN3 DN2 DN1 DN0 D13 D12 D11 D10 D9 D8 D7 D6 D5 D4 D3 D2 \
        D1 D0 RDY DVDD VSS) adc_sarlogic
// @RNL {
//   /* --- semantics --- */
//   {&AVDD &DVDD &AVDD18} @ADD-TO $SUPPLY_NET_SET;
//   &VSS @ADD-TO $GROUND_NET_SET;
//   /* the two halves of the differential front end are matched copies */
//   {#XDACP #XDACN} @AS $MATCHED;
//   {#XBSP #XBSN} @AS $MATCHED;
//   {#XBSP #XDACP} @GROUP;
//   {#XBSN #XDACN} @GROUP;
//   /* the signal path: bootstrap and CDAC of each side, comparator, SAR logic */
//   {#XBSP #XDACP #XCMP #XLOG} @AS(direction="left-to-right") $FLOW;
//   {#XBSN #XDACN #XCMP #XLOG} @AS(direction="left-to-right") $FLOW;
//   /* --- placement --- */
//   #XDACP @PLACE(0, 30) => @ORIENT("MX");
//   #XDACN @PLACE(0, 0);
//   #XBSP @PLACE(-24, 38);
//   #XBSN @PLACE(-24, -8);
//   #XREF @PLACE(-17, 15);
//   #XCMP @PLACE(34, 15);
//   #XLOG @PLACE(54, 15);
//   #XCLK @PLACE(-24, -31);
//   /* --- inputs: VIN to the CDAC, tapped to the bootstrap on the outer side --- */
//   %jvinp = (-38, 26);
//   $JUNCTION @ATTACH %jvinp;
//   %p_vinp = $IO_PORT @ATTACH &VINP => @PLACE(-46, 26) => @ORIENT("R0");
//   &VINP @WIRE {%p_vinp:p %jvinp #XDACP:VIN};
//   &VINP @WIRE {%jvinp (-38, 40) #XBSP:VIN};
//   &VGP @WIRE {#XBSP:VG (-14, 40) (-14, 34) #XDACP:VG};
//   %jvinn = (-38, 4);
//   $JUNCTION @ATTACH %jvinn;
//   %p_vinn = $IO_PORT @ATTACH &VINN => @PLACE(-46, 4) => @ORIENT("R0");
//   &VINN @WIRE {%p_vinn:p %jvinn #XDACN:VIN};
//   &VINN @WIRE {%jvinn (-38, -6) #XBSN:VIN};
//   &VGN @WIRE {#XBSN:VG (-14, -6) (-14, -4) #XDACN:VG};
//   /* --- reference channel: VREFP and VCM from XREF, VREFN tied to VSS --- */
//   %p_vref_in = $IO_PORT @ATTACH &VREF_IN => @PLACE(-46, 15) => @ORIENT("R0");
//   &VREF_IN @WIRE {%p_vref_in:p #XREF:VREF_IN};
//   %jvcm = (-5, 11);
//   $JUNCTION @ATTACH %jvcm;
//   &VCM @WIRE {#XDACP:VCM %jvcm #XDACN:VCM};
//   &VCM @WIRE {#XREF:VCM %jvcm};
//   %jvrp = (-1, 15);
//   $JUNCTION @ATTACH %jvrp;
//   &VREFP @WIRE {#XDACP:VREFP %jvrp #XDACN:VREFP};
//   &VREFP @WIRE {#XREF:VREFP %jvrp};
//   %jvrn = (3, 15);
//   $JUNCTION @ATTACH %jvrn;
//   &VSS @WIRE {#XDACP:VREFN %jvrn #XDACN:VREFN};
//   %g_vrn = $GROUND @ATTACH &VSS => @PLACE(5, 15);
//   &VSS @WIRE {%jvrn %g_vrn:p};
//   /* --- top plates to the comparator, crossed: INP <- TOPN, INN <- TOPP --- */
//   &TOPP @WIRE {#XDACP:TOP (24, 25) (24, 14) #XCMP:INN};
//   &TOPN @WIRE {#XDACN:TOP (26, 5) (26, 16) #XCMP:INP};
//   /* --- comparator <-> SAR logic --- */
//   &OUTP @WIRE {#XCMP:OUTP #XLOG:OUTP};
//   &OUTN @WIRE {#XCMP:OUTN #XLOG:OUTN};
//   &CLKC @WIRE {#XLOG:CLKC (44, 10) (44, 7) (35, 7) #XCMP:CLKC};
//   /* --- SAR loop: UP<12:0> and DN<12:0> to both CDACs (P: RL = UP, DH = DN; N: DH = UP, RL = DN) --- */
//   %jup = (66, 18);
//   $JUNCTION @ATTACH %jup;
//   %jdn = (64, 12);
//   $JUNCTION @ATTACH %jdn;
//   %bus_up_p = {&UP12 &UP11 &UP10 &UP9 &UP8 &UP7 &UP6 &UP5 &UP4 &UP3 &UP2 &UP1 &UP0} @WIRE {#XLOG:UP12 %jup (68, 18) (68, 41) (2, 41) #XDACP:RL12};
//   %bus_up_p @TEXT("UP<12:0>", size=0.7, halign="start") => @PLACE(2.5, 41.3);
//   %bus_up_n = {&UP12 &UP11 &UP10 &UP9 &UP8 &UP7 &UP6 &UP5 &UP4 &UP3 &UP2 &UP1 &UP0} @WIRE {%jup (66, -13) (-4, -13) #XDACN:DH12};
//   %bus_up_n @TEXT("UP<12:0>", size=0.7, halign="start") => @PLACE(-3.5, -14.2);
//   %bus_dn_p = {&DN12 &DN11 &DN10 &DN9 &DN8 &DN7 &DN6 &DN5 &DN4 &DN3 &DN2 &DN1 &DN0} @WIRE {#XLOG:DN12 %jdn (70, 12) (70, 43) (-4, 43) #XDACP:DH12};
//   %bus_dn_p @TEXT("DN<12:0>", size=0.7, halign="start") => @PLACE(-3.5, 43.3);
//   %bus_dn_n = {&DN12 &DN11 &DN10 &DN9 &DN8 &DN7 &DN6 &DN5 &DN4 &DN3 &DN2 &DN1 &DN0} @WIRE {%jdn (64, -11) (2, -11) #XDACN:RL12};
//   %bus_dn_n @TEXT("DN<12:0>", size=0.7, halign="start") => @PLACE(2.5, -12.2);
//   /* --- outputs: the raw bits as one bus port, RDY --- */
//   %p_d = (52, 3)(p) {&D13 &D12 &D11 &D10 &D9 &D8 &D7 &D6 &D5 &D4 &D3 &D2 &D1 &D0}(nets) @AS $BUS_PORT => @ORIENT("R90");
//   %p_d @TEXT("D<13:0>", key="name");
//   %bus_d = {&D13 &D12 &D11 &D10 &D9 &D8 &D7 &D6 &D5 &D4 &D3 &D2 &D1 &D0} @WIRE {#XLOG:D13 %p_d:p};
//   %p_rdy = $IO_PORT @ATTACH &RDY => @PLACE(56, 3) => @ORIENT("R90");
//   &RDY @WIRE {#XLOG:RDY %p_rdy:p};
//   /* --- sampling clock --- */
//   %p_clk = $IO_PORT @ATTACH &CLK => @PLACE(-46, -31) => @ORIENT("R0");
//   &CLK @WIRE {%p_clk:p #XCLK:CLK};
//   /* --- supplies and grounds --- */
//   %s1 = $SUPPLY @ATTACH &AVDD18 => @PLACE(-20, 22);
//   &AVDD18 @WIRE {#XREF:AVDD18 %s1:p};
//   %s2 = $SUPPLY @ATTACH &AVDD => @PLACE(-16, 22);
//   &AVDD @WIRE {#XREF:AVDD %s2:p};
//   %g3 = $GROUND @ATTACH &VSS => @PLACE(-17, 8);
//   &VSS @WIRE {#XREF:VSS %g3:p};
//   %s4 = $SUPPLY @ATTACH &AVDD => @PLACE(-24, -22);
//   &AVDD @WIRE {#XCLK:AVDD %s4:p};
//   %g5 = $GROUND @ATTACH &VSS => @PLACE(-24, -40);
//   &VSS @WIRE {#XCLK:VSS %g5:p};
//   %s6 = $SUPPLY @ATTACH &AVDD => @PLACE(-24, 45);
//   &AVDD @WIRE {#XBSP:AVDD %s6:p};
//   %g7 = $GROUND @ATTACH &VSS => @PLACE(-20, 31);
//   &VSS @WIRE {#XBSP:VSS %g7:p};
//   %s8 = $SUPPLY @ATTACH &AVDD => @PLACE(-24, -1);
//   &AVDD @WIRE {#XBSN:AVDD %s8:p};
//   %g9 = $GROUND @ATTACH &VSS => @PLACE(-20, -15);
//   &VSS @WIRE {#XBSN:VSS %g9:p};
//   %s10 = $SUPPLY @ATTACH &DVDD => @PLACE(19, 28);
//   &DVDD @WIRE {#XDACP:DVDD (12, 30) (12, 28) %s10:p};
//   %g11 = $GROUND @ATTACH &VSS => @PLACE(14, 34);
//   &VSS @WIRE {#XDACP:VSS %g11:p};
//   %s12 = $SUPPLY @ATTACH &DVDD => @PLACE(13, 0);
//   &DVDD @WIRE {#XDACN:DVDD %s12:p};
//   %g13 = $GROUND @ATTACH &VSS => @PLACE(13, -4);
//   &VSS @WIRE {#XDACN:VSS %g13:p};
//   %s14 = $SUPPLY @ATTACH &AVDD => @PLACE(32, 22);
//   &AVDD @WIRE {#XCMP:AVDD %s14:p};
//   %g15 = $GROUND @ATTACH &VSS => @PLACE(32, 8);
//   &VSS @WIRE {#XCMP:VSS %g15:p};
//   %s16 = $SUPPLY @ATTACH &DVDD => @PLACE(54, 25);
//   &DVDD @WIRE {#XLOG:DVDD %s16:p};
//   %g17 = $GROUND @ATTACH &VSS => @PLACE(59, 5);
//   &VSS @WIRE {#XLOG:VSS %g17:p};
//   /* --- phases, connected by net name --- */
//   &PHI_S @WIRE {#XCLK:PHI_S (-16, -27)};
//   (-15.7, -27.25) @TEXT("PHI_S", size=0.6, halign="start");
//   &PHI_SB @WIRE {#XCLK:PHI_SB (-16, -29)};
//   (-15.7, -29.25) @TEXT("PHI_SB", size=0.6, halign="start");
//   &PHI_B @WIRE {#XCLK:PHI_B (-16, -31)};
//   (-15.7, -31.25) @TEXT("PHI_B", size=0.6, halign="start");
//   &PHI_BB @WIRE {#XCLK:PHI_BB (-16, -33)};
//   (-15.7, -33.25) @TEXT("PHI_BB", size=0.6, halign="start");
//   &CONV @WIRE {#XCLK:CONV (-16, -35)};
//   (-15.7, -35.25) @TEXT("CONV", size=0.6, halign="start");
//   &PHI_B @WIRE {#XBSP:PHI_B (-32, 38)};
//   (-32.3, 37.75) @TEXT("PHI_B", size=0.6, halign="end");
//   &PHI_BB @WIRE {#XBSP:PHI_BB (-32, 36)};
//   (-32.3, 35.75) @TEXT("PHI_BB", size=0.6, halign="end");
//   &PHI_B @WIRE {#XBSN:PHI_B (-32, -8)};
//   (-32.3, -8.25) @TEXT("PHI_B", size=0.6, halign="end");
//   &PHI_BB @WIRE {#XBSN:PHI_BB (-32, -10)};
//   (-32.3, -10.25) @TEXT("PHI_BB", size=0.6, halign="end");
//   &PHI_S @WIRE {#XDACP:PHI_S (-13, 28)};
//   (-13.3, 27.75) @TEXT("PHI_S", size=0.6, halign="end");
//   &PHI_SB @WIRE {#XDACP:PHI_SB (-13, 30)};
//   (-13.3, 29.75) @TEXT("PHI_SB", size=0.6, halign="end");
//   &CONV @WIRE {#XDACP:CONV (-13, 32)};
//   (-13.3, 31.75) @TEXT("CONV", size=0.6, halign="end");
//   &PHI_S @WIRE {#XDACN:PHI_S (-13, 2)};
//   (-13.3, 1.75) @TEXT("PHI_S", size=0.6, halign="end");
//   &PHI_SB @WIRE {#XDACN:PHI_SB (-13, 0)};
//   (-13.3, -0.25) @TEXT("PHI_SB", size=0.6, halign="end");
//   &CONV @WIRE {#XDACN:CONV (-13, -2)};
//   (-13.3, -2.25) @TEXT("CONV", size=0.6, halign="end");
//   &CONV @WIRE {#XLOG:CONV (45, 20)};
//   (44.7, 19.75) @TEXT("CONV", size=0.6, halign="end");
//   /* --- annotations --- */
//   (-46, 52) @TEXT("adc_top: 100 MS/s asynchronous SAR, bottom-plate sampling, split-capacitor redundant CDAC", halign="start") => @SET-STYLE $title_style;
//   (-46, 50.3) @TEXT("14 decisions, raw bits D<13:0> with weights 2048 1024 512 384 256 128 64 64 32 16 8 4 2 1; code = sum(W*D)", halign="start") => @SET-STYLE $note_style;
//   (-46, 49) @TEXT("P CDAC drawn mirrored (MX): its control buses on top. P side: RL<j> = UP<j>, DH<j> = DN<j>; N side: DH<j> = UP<j>, RL<j> = DN<j>. Phases connect by net name.", halign="start") => @SET-STYLE $note_style;
//   (34, 2.4) @TEXT("TOPN \to INP, TOPP \to INN (crossed): OUTP = 1 means UP", halign="middle") => @SET-STYLE $note_style
// }
ends adc_top
