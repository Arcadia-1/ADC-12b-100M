// tb_ref_dc: VREFP / VCM accuracy, load and line regulation, currents
// @RNL(type="header") {
//   @VERSION("0.3");
//   @USE-PACKAGE(name="adc28", version="0.1", path="../../design/rnl/adc28.rnl")
// }
// generated by `python -m adcflow gen` from specs/ -- do not edit (tools/adcflow/gen_tb.py)
// Globals vdd, vdd18, tempc, noise_en, devnoise, beh_speed, vref_in come from the run deck.
simulator lang=spectre
parameters iload=100u
XDUT (VREF_IN VREFP VCM AVDD18 AVDD 0) adc_ref
VREF (VREF_IN 0) vsource dc=vref_in
VH (AVDD18 0) vsource dc=vdd18
VA (AVDD 0) vsource dc=vdd
// CDAC average load
IL (VREFP 0) isource dc=iload
dcop dc
dcload dc param=iload start=0 stop=200u step=50u
dcline dc dev=VH param=dc start=vdd18*0.9 stop=vdd18*1.1 step=vdd18*0.05
save VREFP VCM VH:p VA:p VREF:p
// @RNL {
//   /* --- semantics --- */
//   &0 @ADD-TO $GROUND_NET_SET;
//   #XDUT @PLACE(6, 0);
//   #VREF @PLACE(-16, 5);
//   #IL @PLACE(0, -15);
//   #VH @PLACE(0, 17);
//   #VA @PLACE(12, 17);
//   &VREF_IN @WIRE {#XDUT:VREF_IN (-2, 0)};
//   (-2.3, -0.25) @TEXT("VREF_IN", size=0.6, halign="end");
//   &VREFP @WIRE {#XDUT:VREFP (17, 0)};
//   (17.3, -0.25) @TEXT("VREFP", size=0.6, halign="start");
//   &VCM @WIRE {#XDUT:VCM (17, -4)};
//   (17.3, -4.25) @TEXT("VCM", size=0.6, halign="start");
//   &AVDD18 @WIRE {#XDUT:AVDD18 (3, 7)};
//   (3.25, 7.3) @TEXT("AVDD18", size=0.6, rotate=90, halign="start");
//   &AVDD @WIRE {#XDUT:AVDD (7, 7)};
//   (7.25, 7.3) @TEXT("AVDD", size=0.6, rotate=90, halign="start");
//   %g1 = $GROUND @ATTACH &0 => @PLACE(6, -6.5);
//   &0 @WIRE {#XDUT:VSS %g1:p};
//   &VREF_IN @WIRE {#VREF:1 (-16, 9)};
//   (-15.75, 9.3) @TEXT("VREF_IN", size=0.6, rotate=90, halign="start");
//   %g2 = $GROUND @ATTACH &0 => @PLACE(-16, 1.5);
//   &0 @WIRE {#VREF:2 %g2:p};
//   &AVDD18 @WIRE {#VH:1 (0, 21)};
//   (0.25, 21.3) @TEXT("AVDD18", size=0.6, rotate=90, halign="start");
//   %g3 = $GROUND @ATTACH &0 => @PLACE(0, 13.5);
//   &0 @WIRE {#VH:2 %g3:p};
//   &AVDD @WIRE {#VA:1 (12, 21)};
//   (12.25, 21.3) @TEXT("AVDD", size=0.6, rotate=90, halign="start");
//   %g4 = $GROUND @ATTACH &0 => @PLACE(12, 13.5);
//   &0 @WIRE {#VA:2 %g4:p};
//   &VREFP @WIRE {#IL:1 (0, -11)};
//   (0.25, -10.7) @TEXT("VREFP", size=0.6, rotate=90, halign="start");
//   %g5 = $GROUND @ATTACH &0 => @PLACE(0, -18.5);
//   &0 @WIRE {#IL:2 %g5:p};
//   (-30, 31) @TEXT("tb_ref_dc: VREFP / VCM accuracy, load and line regulation, currents", halign="start") => @SET-STYLE $title_style
// }
