// tb_ref_dyn: VREFP under the CDAC conversion load pattern
// @RNL(type="header") {
//   @VERSION("0.3");
//   @USE-PACKAGE(name="adc28", version="0.1", path="../../design/rnl/adc28.rnl")
// }
// generated by `python -m adcflow gen` from specs/ -- do not edit (tools/adcflow/gen_tb.py)
// Globals vdd, vdd18, tempc, noise_en, devnoise, beh_speed, vref_in come from the run deck.
simulator lang=spectre
parameters tsettle=2u nconv=256
parameters tstop=tsettle+nconv*10n
XDUT (VREF_IN VREFP VCM AVDD18 AVDD 0) adc_ref
VREF (VREF_IN 0) vsource dc=vref_in
VH (AVDD18 0) vsource dc=vdd18
VA (AVDD 0) vsource dc=vdd
VCLK (CLK 0) vsource type=pulse val0=0 val1=vdd period=10n width=4.98n rise=20p fall=20p
// 1 pC per conversion, every 64 conversions 20 % more charge in the decision pulses
ILD (CLK VREFP 0) tb_refload_va nalt=64 heavy=1.2
// VREFP at every conversion start
ISMP (VREFP 0 CLK 0) tb_sampler_va dir=-1 delay=0 fname="vstart.txt"
tran1 tran stop=tstop outputstart=tstop-200n
save VREFP
// @RNL {
//   /* --- semantics --- */
//   &0 @ADD-TO $GROUND_NET_SET;
//   #XDUT @PLACE(7, 0);
//   #VREF @PLACE(-16, 4);
//   #VCLK @PLACE(-16, -5);
//   #ISMP @PLACE(37, 3);
//   #ILD @PLACE(0, -14);
//   #VH @PLACE(0, 16);
//   #VA @PLACE(12, 16);
//   &VREF_IN @WIRE {#XDUT:VREF_IN (-2, 0)};
//   (-2.3, -0.25) @TEXT("VREF_IN", size=0.6, halign="end");
//   &VREFP @WIRE {#XDUT:VREFP (16, 1)};
//   (16.3, 0.75) @TEXT("VREFP", size=0.6, halign="start");
//   &VCM @WIRE {#XDUT:VCM (16, -1)};
//   (16.3, -1.25) @TEXT("VCM", size=0.6, halign="start");
//   &AVDD18 @WIRE {#XDUT:AVDD18 (5, 6)};
//   (5.25, 6.3) @TEXT("AVDD18", size=0.6, rotate=90, halign="start");
//   &AVDD @WIRE {#XDUT:AVDD (9, 6)};
//   (9.25, 6.3) @TEXT("AVDD", size=0.6, rotate=90, halign="start");
//   %g1 = $GROUND @ATTACH &0 => @PLACE(7, -5.5);
//   &0 @WIRE {#XDUT:VSS %g1:p};
//   &VREF_IN @WIRE {#VREF:1 (-16, 8)};
//   (-15.75, 8.3) @TEXT("VREF_IN", size=0.6, rotate=90, halign="start");
//   %g2 = $GROUND @ATTACH &0 => @PLACE(-16, 0.5);
//   &0 @WIRE {#VREF:2 %g2:p};
//   &AVDD18 @WIRE {#VH:1 (0, 20)};
//   (0.25, 20.3) @TEXT("AVDD18", size=0.6, rotate=90, halign="start");
//   %g3 = $GROUND @ATTACH &0 => @PLACE(0, 12.5);
//   &0 @WIRE {#VH:2 %g3:p};
//   &AVDD @WIRE {#VA:1 (12, 20)};
//   (12.25, 20.3) @TEXT("AVDD", size=0.6, rotate=90, halign="start");
//   %g4 = $GROUND @ATTACH &0 => @PLACE(12, 12.5);
//   &0 @WIRE {#VA:2 %g4:p};
//   &CLK @WIRE {#VCLK:1 (-16, -1)};
//   (-15.75, -0.7) @TEXT("CLK", size=0.6, rotate=90, halign="start");
//   %g5 = $GROUND @ATTACH &0 => @PLACE(-16, -8.5);
//   &0 @WIRE {#VCLK:2 %g5:p};
//   &CLK @WIRE {#ILD:CLK (-9, -14)};
//   (-9.3, -14.25) @TEXT("CLK", size=0.6, halign="end");
//   &VREFP @WIRE {#ILD:P (0, -8)};
//   (0.25, -7.7) @TEXT("VREFP", size=0.6, rotate=90, halign="start");
//   %g6 = $GROUND @ATTACH &0 => @PLACE(0, -19.5);
//   &0 @WIRE {#ILD:N %g6:p};
//   &VREFP @WIRE {#ISMP:P (28, 4)};
//   (27.7, 3.75) @TEXT("VREFP", size=0.6, halign="end");
//   %g7 = $GROUND @ATTACH &0 => @PLACE(28.5, 2);
//   &0 @WIRE {#ISMP:N (28.5, 2) (28.5, 2) %g7:p};
//   &CLK @WIRE {#ISMP:TRIG (35, -3)};
//   (35.25, -3.3) @TEXT("CLK", size=0.6, rotate=90, halign="end");
//   %g8 = $GROUND @ATTACH &0 => @PLACE(39, -2.5);
//   &0 @WIRE {#ISMP:VSS %g8:p};
//   (-30, 30) @TEXT("tb_ref_dyn: VREFP under the CDAC conversion load pattern", halign="start") => @SET-STYLE $title_style
// }
