// tb_clkgen_timing: phase order, delays, skews and edge rates
// @RNL(type="header") {
//   @VERSION("0.3");
//   @USE-PACKAGE(name="adc28", version="0.1", path="../../design/rnl/adc28.rnl")
// }
// generated by `python -m adcflow gen` from specs/ -- do not edit (tools/adcflow/gen_tb.py)
// Globals vdd, vdd18, tempc, noise_en, devnoise, beh_speed, vref_in come from the run deck.
simulator lang=spectre
parameters tstop=161n
XDUT (CLK PHI_S PHI_SB PHI_B PHI_BB CONV AVDD 0) adc_clkgen
// 8 cycles at 50 % duty, 4 at 45 %, 4 at 55 % (20 ps edges)
VCLK (CLK 0) vsource type=pwl wave=[0.0000e+00 0 1.0000e-09 0 1.0200e-09 vdd 6.0000e-09 vdd 6.0200e-09 0 1.1000e-08 0 1.1020e-08 vdd 1.6000e-08 vdd 1.6020e-08 0 2.1000e-08 0 2.1020e-08 vdd 2.6000e-08 vdd 2.6020e-08 0 3.1000e-08 0 3.1020e-08 vdd 3.6000e-08 vdd 3.6020e-08 0 4.1000e-08 0 4.1020e-08 vdd 4.6000e-08 vdd 4.6020e-08 0 5.1000e-08 0 5.1020e-08 vdd 5.6000e-08 vdd 5.6020e-08 0 6.1000e-08 0 6.1020e-08 vdd 6.6000e-08 vdd 6.6020e-08 0 7.1000e-08 0 7.1020e-08 vdd 7.6000e-08 vdd 7.6020e-08 0 8.1000e-08 0 8.1020e-08 vdd 8.5500e-08 vdd 8.5520e-08 0 9.1000e-08 0 9.1020e-08 vdd 9.5500e-08 vdd 9.5520e-08 0 1.0100e-07 0 1.0102e-07 vdd 1.0550e-07 vdd 1.0552e-07 0 1.1100e-07 0 1.1102e-07 vdd 1.1550e-07 vdd 1.1552e-07 0 1.2100e-07 0 1.2102e-07 vdd 1.2650e-07 vdd 1.2652e-07 0 1.3100e-07 0 1.3102e-07 vdd 1.3650e-07 vdd 1.3652e-07 0 1.4100e-07 0 1.4102e-07 vdd 1.4650e-07 vdd 1.4652e-07 0 1.5100e-07 0 1.5102e-07 vdd 1.5650e-07 vdd 1.5652e-07 0]
CLPHI_S (PHI_S 0) capacitor c=60f
CLPHI_SB (PHI_SB 0) capacitor c=60f
CLPHI_B (PHI_B 0) capacitor c=40f
CLPHI_BB (PHI_BB 0) capacitor c=40f
CLCONV (CONV 0) capacitor c=250f
VAVDD (AVDD_S 0) vsource dc=vdd
IMAVDD (AVDD_S AVDD) tb_imeter_va tstart=10n tstop=80n label="AVDD" fname="power.txt"
tran1 tran stop=tstop maxstep=2p
save CLK PHI_S PHI_SB PHI_B PHI_BB CONV
// @RNL {
//   /* --- semantics --- */
//   &0 @ADD-TO $GROUND_NET_SET;
//   #XDUT @PLACE(7, 0);
//   #VCLK @PLACE(-16, 7);
//   #CLPHI_S @PLACE(0, -17);
//   #CLPHI_SB @PLACE(8, -17);
//   #CLPHI_B @PLACE(16, -17);
//   #CLPHI_BB @PLACE(24, -17);
//   #CLCONV @PLACE(32, -17);
//   #VAVDD @PLACE(0, 19);
//   #IMAVDD @PLACE(12, 21);
//   &CLK @WIRE {#XDUT:CLK (-2, 0)};
//   (-2.3, -0.25) @TEXT("CLK", size=0.6, halign="end");
//   &PHI_S @WIRE {#XDUT:PHI_S (16, 4)};
//   (16.3, 3.75) @TEXT("PHI_S", size=0.6, halign="start");
//   &PHI_SB @WIRE {#XDUT:PHI_SB (16, 2)};
//   (16.3, 1.75) @TEXT("PHI_SB", size=0.6, halign="start");
//   &PHI_B @WIRE {#XDUT:PHI_B (16, 0)};
//   (16.3, -0.25) @TEXT("PHI_B", size=0.6, halign="start");
//   &PHI_BB @WIRE {#XDUT:PHI_BB (16, -2)};
//   (16.3, -2.25) @TEXT("PHI_BB", size=0.6, halign="start");
//   &CONV @WIRE {#XDUT:CONV (16, -4)};
//   (16.3, -4.25) @TEXT("CONV", size=0.6, halign="start");
//   &AVDD @WIRE {#XDUT:AVDD (7, 9)};
//   (7.25, 9.3) @TEXT("AVDD", size=0.6, rotate=90, halign="start");
//   %g1 = $GROUND @ATTACH &0 => @PLACE(7, -8.5);
//   &0 @WIRE {#XDUT:VSS %g1:p};
//   &CLK @WIRE {#VCLK:1 (-16, 11)};
//   (-15.75, 11.3) @TEXT("CLK", size=0.6, rotate=90, halign="start");
//   %g2 = $GROUND @ATTACH &0 => @PLACE(-16, 3.5);
//   &0 @WIRE {#VCLK:2 %g2:p};
//   &PHI_S @WIRE {#CLPHI_S:1 (0, -13)};
//   (0.25, -12.7) @TEXT("PHI_S", size=0.6, rotate=90, halign="start");
//   %g3 = $GROUND @ATTACH &0 => @PLACE(0, -20.5);
//   &0 @WIRE {#CLPHI_S:2 %g3:p};
//   &PHI_SB @WIRE {#CLPHI_SB:1 (8, -13)};
//   (8.25, -12.7) @TEXT("PHI_SB", size=0.6, rotate=90, halign="start");
//   %g4 = $GROUND @ATTACH &0 => @PLACE(8, -20.5);
//   &0 @WIRE {#CLPHI_SB:2 %g4:p};
//   &PHI_B @WIRE {#CLPHI_B:1 (16, -13)};
//   (16.25, -12.7) @TEXT("PHI_B", size=0.6, rotate=90, halign="start");
//   %g5 = $GROUND @ATTACH &0 => @PLACE(16, -20.5);
//   &0 @WIRE {#CLPHI_B:2 %g5:p};
//   &PHI_BB @WIRE {#CLPHI_BB:1 (24, -13)};
//   (24.25, -12.7) @TEXT("PHI_BB", size=0.6, rotate=90, halign="start");
//   %g6 = $GROUND @ATTACH &0 => @PLACE(24, -20.5);
//   &0 @WIRE {#CLPHI_BB:2 %g6:p};
//   &CONV @WIRE {#CLCONV:1 (32, -13)};
//   (32.25, -12.7) @TEXT("CONV", size=0.6, rotate=90, halign="start");
//   %g7 = $GROUND @ATTACH &0 => @PLACE(32, -20.5);
//   &0 @WIRE {#CLCONV:2 %g7:p};
//   &AVDD_S @WIRE {#VAVDD:1 (0, 23)};
//   (0.25, 23.3) @TEXT("AVDD_S", size=0.6, rotate=90, halign="start");
//   %g8 = $GROUND @ATTACH &0 => @PLACE(0, 15.5);
//   &0 @WIRE {#VAVDD:2 %g8:p};
//   &AVDD_S @WIRE {#IMAVDD:P (12, 27)};
//   (12.25, 27.3) @TEXT("AVDD_S", size=0.6, rotate=90, halign="start");
//   &AVDD @WIRE {#IMAVDD:N (12, 15)};
//   (12.25, 14.7) @TEXT("AVDD", size=0.6, rotate=90, halign="end");
//   (-30, 33) @TEXT("tb_clkgen_timing: phase order, delays, skews and edge rates", halign="start") => @SET-STYLE $title_style
// }
