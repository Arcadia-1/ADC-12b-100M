// tb_sarlogic_func: SAR controller against a comparator emulator
// @RNL(type="header") {
//   @VERSION("0.3");
//   @USE-PACKAGE(name="adc28", version="0.1", path="../../design/rnl/adc28.rnl")
// }
// generated by `python -m adcflow gen` from specs/ -- do not edit (tools/adcflow/gen_tb.py)
// Globals vdd, vdd18, tempc, noise_en, devnoise, beh_speed, vref_in come from the run deck.
simulator lang=spectre
parameters nconv=60 t0cmp=45p stuck=0 nowave=0 tper=10n tconv=4.8n tdel=0.12n cupdn=12f cclk=20f cload=50f
parameters tstop=nconv*tper+tdel+1n
XDUT (CONV OUTP OUTN CLKC UP12 UP11 UP10 UP9 UP8 UP7 UP6 UP5 UP4 UP3 UP2 UP1 UP0 DN12 DN11 \
        DN10 DN9 DN8 DN7 DN6 DN5 DN4 DN3 DN2 DN1 DN0 D13 D12 D11 D10 D9 D8 D7 D6 D5 D4 D3 D2 \
        D1 D0 RDY DVDD 0) adc_sarlogic
// conversion window as adc_clkgen makes it
VCONV (CONV 0) vsource type=pulse val0=0 val1=vdd period=tper delay=tdel width=tconv-20p rise=20p fall=20p
VCONVB (CONVB 0) vsource type=pulse val0=vdd val1=0 period=tper delay=tdel width=tconv-20p rise=20p fall=20p
VDDE (VDDE 0) vsource dc=vdd
// comparator emulator: random input per conversion, decision from the UP/DN DAC level
IEMU (CONV CLKC UP12 UP11 UP10 UP9 UP8 UP7 UP6 UP5 UP4 UP3 UP2 UP1 UP0 DN12 DN11 DN10 DN9 \
        DN8 DN7 DN6 DN5 DN4 DN3 DN2 DN1 DN0 OUTP OUTN VDDE 0) tb_cmp_emu_va t0=t0cmp tau=8p cload=cupdn cclk=cclk stuck_k=stuck fname="emu.txt"
ICAP (CONVB RDY D13 D12 D11 D10 D9 D8 D7 D6 D5 D4 D3 D2 D1 D0 0) tb_capture_va vth=vdd/2 cload=cload fname="capture.txt"
VDVDD (DVDD_S 0) vsource dc=vdd
IMDVDD (DVDD_S DVDD) tb_imeter_va tstart=tper tstop=tstop label="DVDD" fname="power.txt"
tran1 tran stop=tstop outputstart=nowave*tstop
save CONV CLKC OUTP OUTN RDY UP12 DN12 UP6 DN6 UP0 DN0 D0
// @RNL {
//   /* --- semantics --- */
//   &0 @ADD-TO $GROUND_NET_SET;
//   #XDUT @PLACE(7, 0);
//   #VCONV @PLACE(-16, 8);
//   #VCONVB @PLACE(-16, -1);
//   #VDDE @PLACE(-16, -10);
//   #IEMU @PLACE(38, 2);
//   #ICAP @PLACE(37, -16);
//   #VDVDD @PLACE(0, 20);
//   #IMDVDD @PLACE(12, 21);
//   &CONV @WIRE {#XDUT:CONV (-2, 5)};
//   (-2.3, 4.75) @TEXT("CONV", size=0.6, halign="end");
//   &OUTP @WIRE {#XDUT:OUTP (-2, 1)};
//   (-2.3, 0.75) @TEXT("OUTP", size=0.6, halign="end");
//   &OUTN @WIRE {#XDUT:OUTN (-2, -1)};
//   (-2.3, -1.25) @TEXT("OUTN", size=0.6, halign="end");
//   &CLKC @WIRE {#XDUT:CLKC (-2, -5)};
//   (-2.3, -5.25) @TEXT("CLKC", size=0.6, halign="end");
//   {&UP12 &UP11 &UP10 &UP9 &UP8 &UP7 &UP6 &UP5 &UP4 &UP3 &UP2 &UP1 &UP0} @WIRE {#XDUT:UP12 (17, 3)};
//   (17.3, 2.75) @TEXT("UP<12:0>", size=0.6, halign="start");
//   {&DN12 &DN11 &DN10 &DN9 &DN8 &DN7 &DN6 &DN5 &DN4 &DN3 &DN2 &DN1 &DN0} @WIRE {#XDUT:DN12 (17, -3)};
//   (17.3, -3.25) @TEXT("DN<12:0>", size=0.6, halign="start");
//   {&D13 &D12 &D11 &D10 &D9 &D8 &D7 &D6 &D5 &D4 &D3 &D2 &D1 &D0} @WIRE {#XDUT:D13 (5, -11)};
//   (5.25, -11.3) @TEXT("D<13:0>", size=0.6, rotate=90, halign="end");
//   &RDY @WIRE {#XDUT:RDY (9, -10)};
//   (9.25, -10.3) @TEXT("RDY", size=0.6, rotate=90, halign="end");
//   &DVDD @WIRE {#XDUT:DVDD (7, 10)};
//   (7.25, 10.3) @TEXT("DVDD", size=0.6, rotate=90, halign="start");
//   %g1 = $GROUND @ATTACH &0 => @PLACE(12, -9.5);
//   &0 @WIRE {#XDUT:VSS %g1:p};
//   &CONV @WIRE {#VCONV:1 (-16, 12)};
//   (-15.75, 12.3) @TEXT("CONV", size=0.6, rotate=90, halign="start");
//   %g2 = $GROUND @ATTACH &0 => @PLACE(-16, 4.5);
//   &0 @WIRE {#VCONV:2 %g2:p};
//   &CONVB @WIRE {#VCONVB:1 (-16, 3)};
//   (-15.75, 3.3) @TEXT("CONVB", size=0.6, rotate=90, halign="start");
//   %g3 = $GROUND @ATTACH &0 => @PLACE(-16, -4.5);
//   &0 @WIRE {#VCONVB:2 %g3:p};
//   &VDDE @WIRE {#VDDE:1 (-16, -6)};
//   (-15.75, -5.7) @TEXT("VDDE", size=0.6, rotate=90, halign="start");
//   %g4 = $GROUND @ATTACH &0 => @PLACE(-16, -13.5);
//   &0 @WIRE {#VDDE:2 %g4:p};
//   &CONV @WIRE {#IEMU:CONV (29, 5)};
//   (28.7, 4.75) @TEXT("CONV", size=0.6, halign="end");
//   &CLKC @WIRE {#IEMU:CLKC (29, 3)};
//   (28.7, 2.75) @TEXT("CLKC", size=0.6, halign="end");
//   {&UP12 &UP11 &UP10 &UP9 &UP8 &UP7 &UP6 &UP5 &UP4 &UP3 &UP2 &UP1 &UP0} @WIRE {#IEMU:UP12 (48, 4)};
//   (48.3, 3.75) @TEXT("UP<12:0>", size=0.6, halign="start");
//   {&DN12 &DN11 &DN10 &DN9 &DN8 &DN7 &DN6 &DN5 &DN4 &DN3 &DN2 &DN1 &DN0} @WIRE {#IEMU:DN12 (48, 0)};
//   (48.3, -0.25) @TEXT("DN<12:0>", size=0.6, halign="start");
//   &OUTP @WIRE {#IEMU:OUTP (29, 1)};
//   (28.7, 0.75) @TEXT("OUTP", size=0.6, halign="end");
//   &OUTN @WIRE {#IEMU:OUTN (29, -1)};
//   (28.7, -1.25) @TEXT("OUTN", size=0.6, halign="end");
//   &VDDE @WIRE {#IEMU:VDD (38, 10)};
//   (38.25, 10.3) @TEXT("VDDE", size=0.6, rotate=90, halign="start");
//   %g5 = $GROUND @ATTACH &0 => @PLACE(38, -5.5);
//   &0 @WIRE {#IEMU:VSS %g5:p};
//   &CONVB @WIRE {#ICAP:CLK (30, -14)};
//   (29.7, -14.25) @TEXT("CONVB", size=0.6, halign="end");
//   &RDY @WIRE {#ICAP:RDY (30, -16)};
//   (29.7, -16.25) @TEXT("RDY", size=0.6, halign="end");
//   {&D13 &D12 &D11 &D10 &D9 &D8 &D7 &D6 &D5 &D4 &D3 &D2 &D1 &D0} @WIRE {#ICAP:D13 (29, -18)};
//   (28.7, -18.25) @TEXT("D<13:0>", size=0.6, halign="end");
//   %g6 = $GROUND @ATTACH &0 => @PLACE(37, -22.5);
//   &0 @WIRE {#ICAP:VSS %g6:p};
//   &DVDD_S @WIRE {#VDVDD:1 (0, 24)};
//   (0.25, 24.3) @TEXT("DVDD_S", size=0.6, rotate=90, halign="start");
//   %g7 = $GROUND @ATTACH &0 => @PLACE(0, 16.5);
//   &0 @WIRE {#VDVDD:2 %g7:p};
//   &DVDD_S @WIRE {#IMDVDD:P (12, 26)};
//   (12.25, 26.3) @TEXT("DVDD_S", size=0.6, rotate=90, halign="start");
//   &DVDD @WIRE {#IMDVDD:N (12, 16)};
//   (12.25, 15.7) @TEXT("DVDD", size=0.6, rotate=90, halign="end");
//   (-30, 34) @TEXT("tb_sarlogic_func: SAR controller against a comparator emulator", halign="start") => @SET-STYLE $title_style;
//   (-30, 32.4) @TEXT("UP/DN loaded by cupdn and CLKC by cclk inside the emulator, D/RDY by cload inside the capture", halign="start") => @SET-STYLE $note_style;
//   (-30, 30.8) @TEXT("stuck=k: the emulator never answers decision k of every odd conversion (timeout test); nowave=1 writes no waveforms (long functional runs)", halign="start") => @SET-STYLE $note_style
// }
