// tb_sarlogic_func: SAR controller against a comparator emulator
// @RNL(type="header") {
//   @VERSION("0.3");
//   @USE-PACKAGE(name="adc28", version="0.1", path="../../design/rnl/adc28.rnl")
// }
// generated by `python -m adcflow gen` from specs/ -- do not edit (tools/adcflow/gen_tb.py)
// Globals vdd, vdd18, tempc, noise_en, devnoise, beh_speed, vref_in come from the run deck.
simulator lang=spectre
parameters nconv=60 t0cmp=45p stuck=0 nowave=0 tper=10n tconv=4.8n tdel=0.12n cupdn=12f cclk=20f cload=50f
parameters tstop=nconv*tper+tdel+1n
XDUT (CONV OUTP OUTN CLKC UP12 UP11 UP10 UP9 UP8 UP7 UP6 UP5 UP4 UP3 UP2 UP1 UP0 DN12 DN11 \
        DN10 DN9 DN8 DN7 DN6 DN5 DN4 DN3 DN2 DN1 DN0 D13 D12 D11 D10 D9 D8 D7 D6 D5 D4 D3 D2 \
        D1 D0 RDY DVDD 0) adc_sarlogic
// conversion window as adc_clkgen makes it
VCONV (CONV 0) vsource type=pulse val0=0 val1=vdd period=tper delay=tdel width=tconv-20p rise=20p fall=20p
VCONVB (CONVB 0) vsource type=pulse val0=vdd val1=0 period=tper delay=tdel width=tconv-20p rise=20p fall=20p
VDDE (VDDE 0) vsource dc=vdd
// comparator emulator: random input per conversion, decision from the UP/DN DAC level
IEMU (CONV CLKC UP12 UP11 UP10 UP9 UP8 UP7 UP6 UP5 UP4 UP3 UP2 UP1 UP0 DN12 DN11 DN10 DN9 \
        DN8 DN7 DN6 DN5 DN4 DN3 DN2 DN1 DN0 OUTP OUTN VDDE 0) tb_cmp_emu_va t0=t0cmp tau=8p cload=cupdn cclk=cclk stuck_k=stuck fname="emu.txt"
ICAP (CONVB RDY D13 D12 D11 D10 D9 D8 D7 D6 D5 D4 D3 D2 D1 D0 0) tb_capture_va vth=vdd/2 cload=cload fname="capture.txt"
VDVDD (DVDD_S 0) vsource dc=vdd
IMDVDD (DVDD_S DVDD) tb_imeter_va tstart=tper tstop=tstop label="DVDD" fname="power.txt"
tran1 tran stop=tstop outputstart=nowave*tstop
save CONV CLKC OUTP OUTN RDY UP12 DN12 UP6 DN6 UP0 DN0 D0
// @RNL {
//   /* --- semantics --- */
//   &0 @ADD-TO $GROUND_NET_SET;
//   #XDUT @PLACE(17, 0);
//   #VCONV @PLACE(-16, 28);
//   #VCONVB @PLACE(-16, 19);
//   #VDDE @PLACE(-16, 10);
//   #IEMU @PLACE(57, 0);
//   #ICAP @PLACE(57, -53);
//   #VDVDD @PLACE(0, 40);
//   #IMDVDD @PLACE(12, 42);
//   &CONV @WIRE {#XDUT:CONV (-2, 3)};
//   (-2.3, 2.75) @TEXT("CONV", size=0.6, halign="end");
//   &OUTP @WIRE {#XDUT:OUTP (-2, 1)};
//   (-2.3, 0.75) @TEXT("OUTP", size=0.6, halign="end");
//   &OUTN @WIRE {#XDUT:OUTN (-2, -1)};
//   (-2.3, -1.25) @TEXT("OUTN", size=0.6, halign="end");
//   &CLKC @WIRE {#XDUT:CLKC (-2, -3)};
//   (-2.3, -3.25) @TEXT("CLKC", size=0.6, halign="end");
//   &UP12 @WIRE {#XDUT:UP12 (36, 25)};
//   (36.3, 24.75) @TEXT("UP12", size=0.6, halign="start");
//   &UP11 @WIRE {#XDUT:UP11 (36, 23)};
//   (36.3, 22.75) @TEXT("UP11", size=0.6, halign="start");
//   &UP10 @WIRE {#XDUT:UP10 (36, 21)};
//   (36.3, 20.75) @TEXT("UP10", size=0.6, halign="start");
//   &UP9 @WIRE {#XDUT:UP9 (36, 19)};
//   (36.3, 18.75) @TEXT("UP9", size=0.6, halign="start");
//   &UP8 @WIRE {#XDUT:UP8 (36, 17)};
//   (36.3, 16.75) @TEXT("UP8", size=0.6, halign="start");
//   &UP7 @WIRE {#XDUT:UP7 (36, 15)};
//   (36.3, 14.75) @TEXT("UP7", size=0.6, halign="start");
//   &UP6 @WIRE {#XDUT:UP6 (36, 13)};
//   (36.3, 12.75) @TEXT("UP6", size=0.6, halign="start");
//   &UP5 @WIRE {#XDUT:UP5 (36, 11)};
//   (36.3, 10.75) @TEXT("UP5", size=0.6, halign="start");
//   &UP4 @WIRE {#XDUT:UP4 (36, 9)};
//   (36.3, 8.75) @TEXT("UP4", size=0.6, halign="start");
//   &UP3 @WIRE {#XDUT:UP3 (36, 7)};
//   (36.3, 6.75) @TEXT("UP3", size=0.6, halign="start");
//   &UP2 @WIRE {#XDUT:UP2 (36, 5)};
//   (36.3, 4.75) @TEXT("UP2", size=0.6, halign="start");
//   &UP1 @WIRE {#XDUT:UP1 (36, 3)};
//   (36.3, 2.75) @TEXT("UP1", size=0.6, halign="start");
//   &UP0 @WIRE {#XDUT:UP0 (36, 1)};
//   (36.3, 0.75) @TEXT("UP0", size=0.6, halign="start");
//   &DN12 @WIRE {#XDUT:DN12 (36, -1)};
//   (36.3, -1.25) @TEXT("DN12", size=0.6, halign="start");
//   &DN11 @WIRE {#XDUT:DN11 (36, -3)};
//   (36.3, -3.25) @TEXT("DN11", size=0.6, halign="start");
//   &DN10 @WIRE {#XDUT:DN10 (36, -5)};
//   (36.3, -5.25) @TEXT("DN10", size=0.6, halign="start");
//   &DN9 @WIRE {#XDUT:DN9 (36, -7)};
//   (36.3, -7.25) @TEXT("DN9", size=0.6, halign="start");
//   &DN8 @WIRE {#XDUT:DN8 (36, -9)};
//   (36.3, -9.25) @TEXT("DN8", size=0.6, halign="start");
//   &DN7 @WIRE {#XDUT:DN7 (36, -11)};
//   (36.3, -11.25) @TEXT("DN7", size=0.6, halign="start");
//   &DN6 @WIRE {#XDUT:DN6 (36, -13)};
//   (36.3, -13.25) @TEXT("DN6", size=0.6, halign="start");
//   &DN5 @WIRE {#XDUT:DN5 (36, -15)};
//   (36.3, -15.25) @TEXT("DN5", size=0.6, halign="start");
//   &DN4 @WIRE {#XDUT:DN4 (36, -17)};
//   (36.3, -17.25) @TEXT("DN4", size=0.6, halign="start");
//   &DN3 @WIRE {#XDUT:DN3 (36, -19)};
//   (36.3, -19.25) @TEXT("DN3", size=0.6, halign="start");
//   &DN2 @WIRE {#XDUT:DN2 (36, -21)};
//   (36.3, -21.25) @TEXT("DN2", size=0.6, halign="start");
//   &DN1 @WIRE {#XDUT:DN1 (36, -23)};
//   (36.3, -23.25) @TEXT("DN1", size=0.6, halign="start");
//   &DN0 @WIRE {#XDUT:DN0 (36, -25)};
//   (36.3, -25.25) @TEXT("DN0", size=0.6, halign="start");
//   &D13 @WIRE {#XDUT:D13 (3, -30)};
//   (3.25, -30.3) @TEXT("D13", size=0.6, rotate=90, halign="end");
//   &D12 @WIRE {#XDUT:D12 (5, -30)};
//   (5.25, -30.3) @TEXT("D12", size=0.6, rotate=90, halign="end");
//   &D11 @WIRE {#XDUT:D11 (7, -30)};
//   (7.25, -30.3) @TEXT("D11", size=0.6, rotate=90, halign="end");
//   &D10 @WIRE {#XDUT:D10 (9, -30)};
//   (9.25, -30.3) @TEXT("D10", size=0.6, rotate=90, halign="end");
//   &D9 @WIRE {#XDUT:D9 (11, -30)};
//   (11.25, -30.3) @TEXT("D9", size=0.6, rotate=90, halign="end");
//   &D8 @WIRE {#XDUT:D8 (13, -30)};
//   (13.25, -30.3) @TEXT("D8", size=0.6, rotate=90, halign="end");
//   &D7 @WIRE {#XDUT:D7 (15, -30)};
//   (15.25, -30.3) @TEXT("D7", size=0.6, rotate=90, halign="end");
//   &D6 @WIRE {#XDUT:D6 (17, -30)};
//   (17.25, -30.3) @TEXT("D6", size=0.6, rotate=90, halign="end");
//   &D5 @WIRE {#XDUT:D5 (19, -30)};
//   (19.25, -30.3) @TEXT("D5", size=0.6, rotate=90, halign="end");
//   &D4 @WIRE {#XDUT:D4 (21, -30)};
//   (21.25, -30.3) @TEXT("D4", size=0.6, rotate=90, halign="end");
//   &D3 @WIRE {#XDUT:D3 (23, -30)};
//   (23.25, -30.3) @TEXT("D3", size=0.6, rotate=90, halign="end");
//   &D2 @WIRE {#XDUT:D2 (25, -30)};
//   (25.25, -30.3) @TEXT("D2", size=0.6, rotate=90, halign="end");
//   &D1 @WIRE {#XDUT:D1 (27, -30)};
//   (27.25, -30.3) @TEXT("D1", size=0.6, rotate=90, halign="end");
//   &D0 @WIRE {#XDUT:D0 (29, -30)};
//   (29.25, -30.3) @TEXT("D0", size=0.6, rotate=90, halign="end");
//   &RDY @WIRE {#XDUT:RDY (31, -30)};
//   (31.25, -30.3) @TEXT("RDY", size=0.6, rotate=90, halign="end");
//   &DVDD @WIRE {#XDUT:DVDD (16, 30)};
//   (16.25, 30.3) @TEXT("DVDD", size=0.6, rotate=90, halign="start");
//   %g1 = $GROUND @ATTACH &0 => @PLACE(19.5, 29);
//   &0 @WIRE {#XDUT:VSS (18, 29) (19.5, 29) %g1:p};
//   &CONV @WIRE {#VCONV:1 (-16, 32)};
//   (-15.75, 32.3) @TEXT("CONV", size=0.6, rotate=90, halign="start");
//   %g2 = $GROUND @ATTACH &0 => @PLACE(-16, 24.5);
//   &0 @WIRE {#VCONV:2 %g2:p};
//   &CONVB @WIRE {#VCONVB:1 (-16, 23)};
//   (-15.75, 23.3) @TEXT("CONVB", size=0.6, rotate=90, halign="start");
//   %g3 = $GROUND @ATTACH &0 => @PLACE(-16, 15.5);
//   &0 @WIRE {#VCONVB:2 %g3:p};
//   &VDDE @WIRE {#VDDE:1 (-16, 14)};
//   (-15.75, 14.3) @TEXT("VDDE", size=0.6, rotate=90, halign="start");
//   %g4 = $GROUND @ATTACH &0 => @PLACE(-16, 6.5);
//   &0 @WIRE {#VDDE:2 %g4:p};
//   &CONV @WIRE {#IEMU:CONV (48, 3)};
//   (47.7, 2.75) @TEXT("CONV", size=0.6, halign="end");
//   &CLKC @WIRE {#IEMU:CLKC (48, 1)};
//   (47.7, 0.75) @TEXT("CLKC", size=0.6, halign="end");
//   &UP12 @WIRE {#IEMU:UP12 (66, 25)};
//   (66.3, 24.75) @TEXT("UP12", size=0.6, halign="start");
//   &UP11 @WIRE {#IEMU:UP11 (66, 23)};
//   (66.3, 22.75) @TEXT("UP11", size=0.6, halign="start");
//   &UP10 @WIRE {#IEMU:UP10 (66, 21)};
//   (66.3, 20.75) @TEXT("UP10", size=0.6, halign="start");
//   &UP9 @WIRE {#IEMU:UP9 (66, 19)};
//   (66.3, 18.75) @TEXT("UP9", size=0.6, halign="start");
//   &UP8 @WIRE {#IEMU:UP8 (66, 17)};
//   (66.3, 16.75) @TEXT("UP8", size=0.6, halign="start");
//   &UP7 @WIRE {#IEMU:UP7 (66, 15)};
//   (66.3, 14.75) @TEXT("UP7", size=0.6, halign="start");
//   &UP6 @WIRE {#IEMU:UP6 (66, 13)};
//   (66.3, 12.75) @TEXT("UP6", size=0.6, halign="start");
//   &UP5 @WIRE {#IEMU:UP5 (66, 11)};
//   (66.3, 10.75) @TEXT("UP5", size=0.6, halign="start");
//   &UP4 @WIRE {#IEMU:UP4 (66, 9)};
//   (66.3, 8.75) @TEXT("UP4", size=0.6, halign="start");
//   &UP3 @WIRE {#IEMU:UP3 (66, 7)};
//   (66.3, 6.75) @TEXT("UP3", size=0.6, halign="start");
//   &UP2 @WIRE {#IEMU:UP2 (66, 5)};
//   (66.3, 4.75) @TEXT("UP2", size=0.6, halign="start");
//   &UP1 @WIRE {#IEMU:UP1 (66, 3)};
//   (66.3, 2.75) @TEXT("UP1", size=0.6, halign="start");
//   &UP0 @WIRE {#IEMU:UP0 (66, 1)};
//   (66.3, 0.75) @TEXT("UP0", size=0.6, halign="start");
//   &DN12 @WIRE {#IEMU:DN12 (66, -1)};
//   (66.3, -1.25) @TEXT("DN12", size=0.6, halign="start");
//   &DN11 @WIRE {#IEMU:DN11 (66, -3)};
//   (66.3, -3.25) @TEXT("DN11", size=0.6, halign="start");
//   &DN10 @WIRE {#IEMU:DN10 (66, -5)};
//   (66.3, -5.25) @TEXT("DN10", size=0.6, halign="start");
//   &DN9 @WIRE {#IEMU:DN9 (66, -7)};
//   (66.3, -7.25) @TEXT("DN9", size=0.6, halign="start");
//   &DN8 @WIRE {#IEMU:DN8 (66, -9)};
//   (66.3, -9.25) @TEXT("DN8", size=0.6, halign="start");
//   &DN7 @WIRE {#IEMU:DN7 (66, -11)};
//   (66.3, -11.25) @TEXT("DN7", size=0.6, halign="start");
//   &DN6 @WIRE {#IEMU:DN6 (66, -13)};
//   (66.3, -13.25) @TEXT("DN6", size=0.6, halign="start");
//   &DN5 @WIRE {#IEMU:DN5 (66, -15)};
//   (66.3, -15.25) @TEXT("DN5", size=0.6, halign="start");
//   &DN4 @WIRE {#IEMU:DN4 (66, -17)};
//   (66.3, -17.25) @TEXT("DN4", size=0.6, halign="start");
//   &DN3 @WIRE {#IEMU:DN3 (66, -19)};
//   (66.3, -19.25) @TEXT("DN3", size=0.6, halign="start");
//   &DN2 @WIRE {#IEMU:DN2 (66, -21)};
//   (66.3, -21.25) @TEXT("DN2", size=0.6, halign="start");
//   &DN1 @WIRE {#IEMU:DN1 (66, -23)};
//   (66.3, -23.25) @TEXT("DN1", size=0.6, halign="start");
//   &DN0 @WIRE {#IEMU:DN0 (66, -25)};
//   (66.3, -25.25) @TEXT("DN0", size=0.6, halign="start");
//   &OUTP @WIRE {#IEMU:OUTP (48, -1)};
//   (47.7, -1.25) @TEXT("OUTP", size=0.6, halign="end");
//   &OUTN @WIRE {#IEMU:OUTN (48, -3)};
//   (47.7, -3.25) @TEXT("OUTN", size=0.6, halign="end");
//   &VDDE @WIRE {#IEMU:VDD (57, 30)};
//   (57.25, 30.3) @TEXT("VDDE", size=0.6, rotate=90, halign="start");
//   %g5 = $GROUND @ATTACH &0 => @PLACE(57, -29.5);
//   &0 @WIRE {#IEMU:VSS %g5:p};
//   &CONVB @WIRE {#ICAP:CLK (48, -38)};
//   (47.7, -38.25) @TEXT("CONVB", size=0.6, halign="end");
//   &RDY @WIRE {#ICAP:RDY (48, -40)};
//   (47.7, -40.25) @TEXT("RDY", size=0.6, halign="end");
//   &D13 @WIRE {#ICAP:D13 (48, -42)};
//   (47.7, -42.25) @TEXT("D13", size=0.6, halign="end");
//   &D12 @WIRE {#ICAP:D12 (48, -44)};
//   (47.7, -44.25) @TEXT("D12", size=0.6, halign="end");
//   &D11 @WIRE {#ICAP:D11 (48, -46)};
//   (47.7, -46.25) @TEXT("D11", size=0.6, halign="end");
//   &D10 @WIRE {#ICAP:D10 (48, -48)};
//   (47.7, -48.25) @TEXT("D10", size=0.6, halign="end");
//   &D9 @WIRE {#ICAP:D9 (48, -50)};
//   (47.7, -50.25) @TEXT("D9", size=0.6, halign="end");
//   &D8 @WIRE {#ICAP:D8 (48, -52)};
//   (47.7, -52.25) @TEXT("D8", size=0.6, halign="end");
//   &D7 @WIRE {#ICAP:D7 (48, -54)};
//   (47.7, -54.25) @TEXT("D7", size=0.6, halign="end");
//   &D6 @WIRE {#ICAP:D6 (48, -56)};
//   (47.7, -56.25) @TEXT("D6", size=0.6, halign="end");
//   &D5 @WIRE {#ICAP:D5 (48, -58)};
//   (47.7, -58.25) @TEXT("D5", size=0.6, halign="end");
//   &D4 @WIRE {#ICAP:D4 (48, -60)};
//   (47.7, -60.25) @TEXT("D4", size=0.6, halign="end");
//   &D3 @WIRE {#ICAP:D3 (48, -62)};
//   (47.7, -62.25) @TEXT("D3", size=0.6, halign="end");
//   &D2 @WIRE {#ICAP:D2 (48, -64)};
//   (47.7, -64.25) @TEXT("D2", size=0.6, halign="end");
//   &D1 @WIRE {#ICAP:D1 (48, -66)};
//   (47.7, -66.25) @TEXT("D1", size=0.6, halign="end");
//   &D0 @WIRE {#ICAP:D0 (48, -68)};
//   (47.7, -68.25) @TEXT("D0", size=0.6, halign="end");
//   %g6 = $GROUND @ATTACH &0 => @PLACE(57, -72.5);
//   &0 @WIRE {#ICAP:VSS %g6:p};
//   &DVDD_S @WIRE {#VDVDD:1 (0, 44)};
//   (0.25, 44.3) @TEXT("DVDD_S", size=0.6, rotate=90, halign="start");
//   %g7 = $GROUND @ATTACH &0 => @PLACE(0, 36.5);
//   &0 @WIRE {#VDVDD:2 %g7:p};
//   &DVDD_S @WIRE {#IMDVDD:P (12, 48)};
//   (12.25, 48.3) @TEXT("DVDD_S", size=0.6, rotate=90, halign="start");
//   &DVDD @WIRE {#IMDVDD:N (12, 36)};
//   (12.25, 35.7) @TEXT("DVDD", size=0.6, rotate=90, halign="end");
//   (-30, 54) @TEXT("tb_sarlogic_func: SAR controller against a comparator emulator", halign="start") => @SET-STYLE $title_style;
//   (-30, 52.4) @TEXT("UP/DN loaded by cupdn and CLKC by cclk inside the emulator, D/RDY by cload inside the capture", halign="start") => @SET-STYLE $note_style;
//   (-30, 50.8) @TEXT("stuck=k: the emulator never answers decision k of every odd conversion (timeout test); nowave=1 writes no waveforms (long functional runs)", halign="start") => @SET-STYLE $note_style
// }
