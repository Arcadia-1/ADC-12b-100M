// tb_top_sine: full ADC, coherent differential sine from 50 ohm per side
// @RNL(type="header") {
//   @VERSION("0.3");
//   @USE-PACKAGE(name="adc28", version="0.1", path="../../design/rnl/adc28.rnl")
// }
// generated by `python -m adcflow gen` from specs/ -- do not edit (tools/adcflow/gen_tb.py)
// Globals vdd, vdd18, tempc, noise_en, devnoise, beh_speed, vref_in come from the run deck.
simulator lang=spectre
parameters fin=49.8962402e6 amp_dbfs=-1 npts=1024 nskip=4 duty=0.5 fsamp=100e6 \
        fs_peak=0.9987 vcm_in=0.45 rsrc=50 cload=50f nfmax=20G
parameters amp=fs_peak*pow(10, amp_dbfs/20) tper=1/fsamp \
        tstart=(nskip-0.5)*tper tstop=(nskip+npts+0.6)*tper
XDUT (VINP VINN CLK VREF_IN D13 D12 D11 D10 D9 D8 D7 D6 D5 D4 D3 D2 D1 D0 RDY AVDD DVDD \
        AVDD18 0) adc_top
// differential sine, each side through rsrc (no input driver)
VSP (SRCP 0) vsource type=sine sinedc=vcm_in ampl=amp/2 freq=fin
VSN (SRCN 0) vsource type=sine sinedc=vcm_in ampl=-amp/2 freq=fin
RSP (SRCP VINP) resistor r=rsrc
RSN (SRCN VINN) resistor r=rsrc
// sampling clock: high = track
VCLK (CLK 0) vsource type=pulse val0=0 val1=vdd period=tper width=duty*tper-20p rise=20p fall=20p
VREF (VREF_IN 0) vsource dc=vref_in
// one line per RDY rise; also loads every output with cload
ICAP (CLK RDY D13 D12 D11 D10 D9 D8 D7 D6 D5 D4 D3 D2 D1 D0 0) tb_capture_va vth=vdd/2 tstart=tstart cload=cload fname="capture.txt"
VAVDD (AVDD_S 0) vsource dc=vdd
IMAVDD (AVDD_S AVDD) tb_imeter_va tstart=tstart tstop=tstop label="AVDD" fname="power.txt"
VDVDD (DVDD_S 0) vsource dc=vdd
IMDVDD (DVDD_S DVDD) tb_imeter_va tstart=tstart tstop=tstop label="DVDD" fname="power.txt"
VAVDD18 (AVDD18_S 0) vsource dc=vdd18
IMAVDD18 (AVDD18_S AVDD18) tb_imeter_va tstart=tstart tstop=tstop label="AVDD18" fname="power.txt"
tran1 tran stop=tstop noisefmax=nfmax*noise_en*devnoise noiseseed=1 outputstart=tstop
tbopts options save=none
// @RNL {
//   /* --- semantics --- */
//   &0 @ADD-TO $GROUND_NET_SET;
//   #XDUT @PLACE(8, 0);
//   #VSP @PLACE(-16, 7);
//   #VSN @PLACE(-16, -2);
//   #RSP @PLACE(-16, -11);
//   #RSN @PLACE(-16, -20);
//   #VCLK @PLACE(-16, -29);
//   #VREF @PLACE(-16, -38);
//   #ICAP @PLACE(40, 5);
//   #VAVDD @PLACE(0, 19);
//   #IMAVDD @PLACE(12, 20);
//   #VDVDD @PLACE(24, 19);
//   #IMDVDD @PLACE(36, 20);
//   #VAVDD18 @PLACE(48, 19);
//   #IMAVDD18 @PLACE(60, 20);
//   &VINP @WIRE {#XDUT:VINP (-2, 1)};
//   (-2.3, 0.75) @TEXT("VINP", size=0.6, halign="end");
//   &VINN @WIRE {#XDUT:VINN (-2, -1)};
//   (-2.3, -1.25) @TEXT("VINN", size=0.6, halign="end");
//   &CLK @WIRE {#XDUT:CLK (-1, -4)};
//   (-1.3, -4.25) @TEXT("CLK", size=0.6, halign="end");
//   &VREF_IN @WIRE {#XDUT:VREF_IN (-1, 4)};
//   (-1.3, 3.75) @TEXT("VREF_IN", size=0.6, halign="end");
//   {&D13 &D12 &D11 &D10 &D9 &D8 &D7 &D6 &D5 &D4 &D3 &D2 &D1 &D0} @WIRE {#XDUT:D13 (20, 2)};
//   (20.3, 1.75) @TEXT("D<13:0>", size=0.6, halign="start");
//   &RDY @WIRE {#XDUT:RDY (19, -2)};
//   (19.3, -2.25) @TEXT("RDY", size=0.6, halign="start");
//   &AVDD @WIRE {#XDUT:AVDD (6, 9)};
//   (6.25, 9.3) @TEXT("AVDD", size=0.6, rotate=90, halign="start");
//   &DVDD @WIRE {#XDUT:DVDD (10, 9)};
//   (10.25, 9.3) @TEXT("DVDD", size=0.6, rotate=90, halign="start");
//   &AVDD18 @WIRE {#XDUT:AVDD18 (14, 9)};
//   (14.25, 9.3) @TEXT("AVDD18", size=0.6, rotate=90, halign="start");
//   %g1 = $GROUND @ATTACH &0 => @PLACE(10, -8.5);
//   &0 @WIRE {#XDUT:VSS %g1:p};
//   &SRCP @WIRE {#VSP:1 (-16, 11)};
//   (-15.75, 11.3) @TEXT("SRCP", size=0.6, rotate=90, halign="start");
//   %g2 = $GROUND @ATTACH &0 => @PLACE(-16, 3.5);
//   &0 @WIRE {#VSP:2 %g2:p};
//   &SRCN @WIRE {#VSN:1 (-16, 2)};
//   (-15.75, 2.3) @TEXT("SRCN", size=0.6, rotate=90, halign="start");
//   %g3 = $GROUND @ATTACH &0 => @PLACE(-16, -5.5);
//   &0 @WIRE {#VSN:2 %g3:p};
//   &SRCP @WIRE {#RSP:1 (-16, -7)};
//   (-15.75, -6.7) @TEXT("SRCP", size=0.6, rotate=90, halign="start");
//   &VINP @WIRE {#RSP:2 (-16, -15)};
//   (-15.75, -15.3) @TEXT("VINP", size=0.6, rotate=90, halign="end");
//   &SRCN @WIRE {#RSN:1 (-16, -16)};
//   (-15.75, -15.7) @TEXT("SRCN", size=0.6, rotate=90, halign="start");
//   &VINN @WIRE {#RSN:2 (-16, -24)};
//   (-15.75, -24.3) @TEXT("VINN", size=0.6, rotate=90, halign="end");
//   &CLK @WIRE {#VCLK:1 (-16, -25)};
//   (-15.75, -24.7) @TEXT("CLK", size=0.6, rotate=90, halign="start");
//   %g4 = $GROUND @ATTACH &0 => @PLACE(-16, -32.5);
//   &0 @WIRE {#VCLK:2 %g4:p};
//   &VREF_IN @WIRE {#VREF:1 (-16, -34)};
//   (-15.75, -33.7) @TEXT("VREF_IN", size=0.6, rotate=90, halign="start");
//   %g5 = $GROUND @ATTACH &0 => @PLACE(-16, -41.5);
//   &0 @WIRE {#VREF:2 %g5:p};
//   &CLK @WIRE {#ICAP:CLK (33, 7)};
//   (32.7, 6.75) @TEXT("CLK", size=0.6, halign="end");
//   &RDY @WIRE {#ICAP:RDY (33, 5)};
//   (32.7, 4.75) @TEXT("RDY", size=0.6, halign="end");
//   {&D13 &D12 &D11 &D10 &D9 &D8 &D7 &D6 &D5 &D4 &D3 &D2 &D1 &D0} @WIRE {#ICAP:D13 (32, 3)};
//   (31.7, 2.75) @TEXT("D<13:0>", size=0.6, halign="end");
//   %g6 = $GROUND @ATTACH &0 => @PLACE(40, -1.5);
//   &0 @WIRE {#ICAP:VSS %g6:p};
//   &AVDD_S @WIRE {#VAVDD:1 (0, 23)};
//   (0.25, 23.3) @TEXT("AVDD_S", size=0.6, rotate=90, halign="start");
//   %g7 = $GROUND @ATTACH &0 => @PLACE(0, 15.5);
//   &0 @WIRE {#VAVDD:2 %g7:p};
//   &AVDD_S @WIRE {#IMAVDD:P (12, 25)};
//   (12.25, 25.3) @TEXT("AVDD_S", size=0.6, rotate=90, halign="start");
//   &AVDD @WIRE {#IMAVDD:N (12, 15)};
//   (12.25, 14.7) @TEXT("AVDD", size=0.6, rotate=90, halign="end");
//   &DVDD_S @WIRE {#VDVDD:1 (24, 23)};
//   (24.25, 23.3) @TEXT("DVDD_S", size=0.6, rotate=90, halign="start");
//   %g8 = $GROUND @ATTACH &0 => @PLACE(24, 15.5);
//   &0 @WIRE {#VDVDD:2 %g8:p};
//   &DVDD_S @WIRE {#IMDVDD:P (36, 25)};
//   (36.25, 25.3) @TEXT("DVDD_S", size=0.6, rotate=90, halign="start");
//   &DVDD @WIRE {#IMDVDD:N (36, 15)};
//   (36.25, 14.7) @TEXT("DVDD", size=0.6, rotate=90, halign="end");
//   &AVDD18_S @WIRE {#VAVDD18:1 (48, 23)};
//   (48.25, 23.3) @TEXT("AVDD18_S", size=0.6, rotate=90, halign="start");
//   %g9 = $GROUND @ATTACH &0 => @PLACE(48, 15.5);
//   &0 @WIRE {#VAVDD18:2 %g9:p};
//   &AVDD18_S @WIRE {#IMAVDD18:P (60, 25)};
//   (60.25, 25.3) @TEXT("AVDD18_S", size=0.6, rotate=90, halign="start");
//   &AVDD18 @WIRE {#IMAVDD18:N (60, 15)};
//   (60.25, 14.7) @TEXT("AVDD18", size=0.6, rotate=90, halign="end");
//   (-30, 33) @TEXT("tb_top_sine: full ADC, coherent differential sine from 50 ohm per side", halign="start") => @SET-STYLE $title_style;
//   (-30, 31.4) @TEXT("capture.txt: D13..D0 and CLK-fall -> RDY time per conversion; power.txt: average supply currents", halign="start") => @SET-STYLE $note_style
// }
