// tb_top_sine: full ADC, coherent differential sine from 50 ohm per side
// @RNL(type="header") {
//   @VERSION("0.3");
//   @USE-PACKAGE(name="adc28", version="0.1", path="../../design/rnl/adc28.rnl")
// }
// generated by `python -m adcflow gen` from specs/ -- do not edit (tools/adcflow/gen_tb.py)
// Globals vdd, vdd18, tempc, noise_en, devnoise, beh_speed, vref_in come from the run deck.
simulator lang=spectre
parameters fin=49.8962402e6 amp_dbfs=-1 npts=1024 nskip=4 duty=0.5 fsamp=100e6 \
        fs_peak=0.9987 vcm_in=0.45 rsrc=50 cload=50f nfmax=20G
parameters amp=fs_peak*pow(10, amp_dbfs/20) tper=1/fsamp \
        tstart=(nskip-0.5)*tper tstop=(nskip+npts+0.6)*tper
XDUT (VINP VINN CLK VREF_IN D13 D12 D11 D10 D9 D8 D7 D6 D5 D4 D3 D2 D1 D0 RDY AVDD DVDD \
        AVDD18 0) adc_top
// differential sine, each side through rsrc (no input driver)
VSP (SRCP 0) vsource type=sine sinedc=vcm_in ampl=amp/2 freq=fin
VSN (SRCN 0) vsource type=sine sinedc=vcm_in ampl=-amp/2 freq=fin
RSP (SRCP VINP) resistor r=rsrc
RSN (SRCN VINN) resistor r=rsrc
// sampling clock: high = track
VCLK (CLK 0) vsource type=pulse val0=0 val1=vdd period=tper width=duty*tper-20p rise=20p fall=20p
VREF (VREF_IN 0) vsource dc=vref_in
// one line per RDY rise; also loads every output with cload
ICAP (CLK RDY D13 D12 D11 D10 D9 D8 D7 D6 D5 D4 D3 D2 D1 D0 0) tb_capture_va vth=vdd/2 tstart=tstart cload=cload fname="capture.txt"
VAVDD (AVDD_S 0) vsource dc=vdd
IMAVDD (AVDD_S AVDD) tb_imeter_va tstart=tstart tstop=tstop label="AVDD" fname="power.txt"
VDVDD (DVDD_S 0) vsource dc=vdd
IMDVDD (DVDD_S DVDD) tb_imeter_va tstart=tstart tstop=tstop label="DVDD" fname="power.txt"
VAVDD18 (AVDD18_S 0) vsource dc=vdd18
IMAVDD18 (AVDD18_S AVDD18) tb_imeter_va tstart=tstart tstop=tstop label="AVDD18" fname="power.txt"
tran1 tran stop=tstop noisefmax=nfmax*noise_en*devnoise noiseseed=1 outputstart=tstop
tbopts options save=none
// @RNL {
//   /* --- semantics --- */
//   &0 @ADD-TO $GROUND_NET_SET;
//   #XDUT @PLACE(9, 0);
//   #VSP @PLACE(-16, 17);
//   #VSN @PLACE(-16, 8);
//   #RSP @PLACE(-16, -1);
//   #RSN @PLACE(-16, -10);
//   #VCLK @PLACE(-16, -19);
//   #VREF @PLACE(-16, -28);
//   #ICAP @PLACE(41, 2);
//   #VAVDD @PLACE(0, 29);
//   #IMAVDD @PLACE(12, 31);
//   #VDVDD @PLACE(24, 29);
//   #IMDVDD @PLACE(36, 31);
//   #VAVDD18 @PLACE(48, 29);
//   #IMAVDD18 @PLACE(60, 31);
//   &VINP @WIRE {#XDUT:VINP (-2, 3)};
//   (-2.3, 2.75) @TEXT("VINP", size=0.6, halign="end");
//   &VINN @WIRE {#XDUT:VINN (-2, 1)};
//   (-2.3, 0.75) @TEXT("VINN", size=0.6, halign="end");
//   &CLK @WIRE {#XDUT:CLK (-2, -1)};
//   (-2.3, -1.25) @TEXT("CLK", size=0.6, halign="end");
//   &VREF_IN @WIRE {#XDUT:VREF_IN (-2, -3)};
//   (-2.3, -3.25) @TEXT("VREF_IN", size=0.6, halign="end");
//   &D13 @WIRE {#XDUT:D13 (20, 14)};
//   (20.3, 13.75) @TEXT("D13", size=0.6, halign="start");
//   &D12 @WIRE {#XDUT:D12 (20, 12)};
//   (20.3, 11.75) @TEXT("D12", size=0.6, halign="start");
//   &D11 @WIRE {#XDUT:D11 (20, 10)};
//   (20.3, 9.75) @TEXT("D11", size=0.6, halign="start");
//   &D10 @WIRE {#XDUT:D10 (20, 8)};
//   (20.3, 7.75) @TEXT("D10", size=0.6, halign="start");
//   &D9 @WIRE {#XDUT:D9 (20, 6)};
//   (20.3, 5.75) @TEXT("D9", size=0.6, halign="start");
//   &D8 @WIRE {#XDUT:D8 (20, 4)};
//   (20.3, 3.75) @TEXT("D8", size=0.6, halign="start");
//   &D7 @WIRE {#XDUT:D7 (20, 2)};
//   (20.3, 1.75) @TEXT("D7", size=0.6, halign="start");
//   &D6 @WIRE {#XDUT:D6 (20, 0)};
//   (20.3, -0.25) @TEXT("D6", size=0.6, halign="start");
//   &D5 @WIRE {#XDUT:D5 (20, -2)};
//   (20.3, -2.25) @TEXT("D5", size=0.6, halign="start");
//   &D4 @WIRE {#XDUT:D4 (20, -4)};
//   (20.3, -4.25) @TEXT("D4", size=0.6, halign="start");
//   &D3 @WIRE {#XDUT:D3 (20, -6)};
//   (20.3, -6.25) @TEXT("D3", size=0.6, halign="start");
//   &D2 @WIRE {#XDUT:D2 (20, -8)};
//   (20.3, -8.25) @TEXT("D2", size=0.6, halign="start");
//   &D1 @WIRE {#XDUT:D1 (20, -10)};
//   (20.3, -10.25) @TEXT("D1", size=0.6, halign="start");
//   &D0 @WIRE {#XDUT:D0 (20, -12)};
//   (20.3, -12.25) @TEXT("D0", size=0.6, halign="start");
//   &RDY @WIRE {#XDUT:RDY (20, -14)};
//   (20.3, -14.25) @TEXT("RDY", size=0.6, halign="start");
//   &AVDD @WIRE {#XDUT:AVDD (5, 19)};
//   (5.25, 19.3) @TEXT("AVDD", size=0.6, rotate=90, halign="start");
//   &DVDD @WIRE {#XDUT:DVDD (9, 19)};
//   (9.25, 19.3) @TEXT("DVDD", size=0.6, rotate=90, halign="start");
//   &AVDD18 @WIRE {#XDUT:AVDD18 (13, 19)};
//   (13.25, 19.3) @TEXT("AVDD18", size=0.6, rotate=90, halign="start");
//   %g1 = $GROUND @ATTACH &0 => @PLACE(9, -18.5);
//   &0 @WIRE {#XDUT:VSS %g1:p};
//   &SRCP @WIRE {#VSP:1 (-16, 21)};
//   (-15.75, 21.3) @TEXT("SRCP", size=0.6, rotate=90, halign="start");
//   %g2 = $GROUND @ATTACH &0 => @PLACE(-16, 13.5);
//   &0 @WIRE {#VSP:2 %g2:p};
//   &SRCN @WIRE {#VSN:1 (-16, 12)};
//   (-15.75, 12.3) @TEXT("SRCN", size=0.6, rotate=90, halign="start");
//   %g3 = $GROUND @ATTACH &0 => @PLACE(-16, 4.5);
//   &0 @WIRE {#VSN:2 %g3:p};
//   &SRCP @WIRE {#RSP:1 (-16, 3)};
//   (-15.75, 3.3) @TEXT("SRCP", size=0.6, rotate=90, halign="start");
//   &VINP @WIRE {#RSP:2 (-16, -5)};
//   (-15.75, -5.3) @TEXT("VINP", size=0.6, rotate=90, halign="end");
//   &SRCN @WIRE {#RSN:1 (-16, -6)};
//   (-15.75, -5.7) @TEXT("SRCN", size=0.6, rotate=90, halign="start");
//   &VINN @WIRE {#RSN:2 (-16, -14)};
//   (-15.75, -14.3) @TEXT("VINN", size=0.6, rotate=90, halign="end");
//   &CLK @WIRE {#VCLK:1 (-16, -15)};
//   (-15.75, -14.7) @TEXT("CLK", size=0.6, rotate=90, halign="start");
//   %g4 = $GROUND @ATTACH &0 => @PLACE(-16, -22.5);
//   &0 @WIRE {#VCLK:2 %g4:p};
//   &VREF_IN @WIRE {#VREF:1 (-16, -24)};
//   (-15.75, -23.7) @TEXT("VREF_IN", size=0.6, rotate=90, halign="start");
//   %g5 = $GROUND @ATTACH &0 => @PLACE(-16, -31.5);
//   &0 @WIRE {#VREF:2 %g5:p};
//   &CLK @WIRE {#ICAP:CLK (32, 17)};
//   (31.7, 16.75) @TEXT("CLK", size=0.6, halign="end");
//   &RDY @WIRE {#ICAP:RDY (32, 15)};
//   (31.7, 14.75) @TEXT("RDY", size=0.6, halign="end");
//   &D13 @WIRE {#ICAP:D13 (32, 13)};
//   (31.7, 12.75) @TEXT("D13", size=0.6, halign="end");
//   &D12 @WIRE {#ICAP:D12 (32, 11)};
//   (31.7, 10.75) @TEXT("D12", size=0.6, halign="end");
//   &D11 @WIRE {#ICAP:D11 (32, 9)};
//   (31.7, 8.75) @TEXT("D11", size=0.6, halign="end");
//   &D10 @WIRE {#ICAP:D10 (32, 7)};
//   (31.7, 6.75) @TEXT("D10", size=0.6, halign="end");
//   &D9 @WIRE {#ICAP:D9 (32, 5)};
//   (31.7, 4.75) @TEXT("D9", size=0.6, halign="end");
//   &D8 @WIRE {#ICAP:D8 (32, 3)};
//   (31.7, 2.75) @TEXT("D8", size=0.6, halign="end");
//   &D7 @WIRE {#ICAP:D7 (32, 1)};
//   (31.7, 0.75) @TEXT("D7", size=0.6, halign="end");
//   &D6 @WIRE {#ICAP:D6 (32, -1)};
//   (31.7, -1.25) @TEXT("D6", size=0.6, halign="end");
//   &D5 @WIRE {#ICAP:D5 (32, -3)};
//   (31.7, -3.25) @TEXT("D5", size=0.6, halign="end");
//   &D4 @WIRE {#ICAP:D4 (32, -5)};
//   (31.7, -5.25) @TEXT("D4", size=0.6, halign="end");
//   &D3 @WIRE {#ICAP:D3 (32, -7)};
//   (31.7, -7.25) @TEXT("D3", size=0.6, halign="end");
//   &D2 @WIRE {#ICAP:D2 (32, -9)};
//   (31.7, -9.25) @TEXT("D2", size=0.6, halign="end");
//   &D1 @WIRE {#ICAP:D1 (32, -11)};
//   (31.7, -11.25) @TEXT("D1", size=0.6, halign="end");
//   &D0 @WIRE {#ICAP:D0 (32, -13)};
//   (31.7, -13.25) @TEXT("D0", size=0.6, halign="end");
//   %g6 = $GROUND @ATTACH &0 => @PLACE(41, -17.5);
//   &0 @WIRE {#ICAP:VSS %g6:p};
//   &AVDD_S @WIRE {#VAVDD:1 (0, 33)};
//   (0.25, 33.3) @TEXT("AVDD_S", size=0.6, rotate=90, halign="start");
//   %g7 = $GROUND @ATTACH &0 => @PLACE(0, 25.5);
//   &0 @WIRE {#VAVDD:2 %g7:p};
//   &AVDD_S @WIRE {#IMAVDD:P (12, 37)};
//   (12.25, 37.3) @TEXT("AVDD_S", size=0.6, rotate=90, halign="start");
//   &AVDD @WIRE {#IMAVDD:N (12, 25)};
//   (12.25, 24.7) @TEXT("AVDD", size=0.6, rotate=90, halign="end");
//   &DVDD_S @WIRE {#VDVDD:1 (24, 33)};
//   (24.25, 33.3) @TEXT("DVDD_S", size=0.6, rotate=90, halign="start");
//   %g8 = $GROUND @ATTACH &0 => @PLACE(24, 25.5);
//   &0 @WIRE {#VDVDD:2 %g8:p};
//   &DVDD_S @WIRE {#IMDVDD:P (36, 37)};
//   (36.25, 37.3) @TEXT("DVDD_S", size=0.6, rotate=90, halign="start");
//   &DVDD @WIRE {#IMDVDD:N (36, 25)};
//   (36.25, 24.7) @TEXT("DVDD", size=0.6, rotate=90, halign="end");
//   &AVDD18_S @WIRE {#VAVDD18:1 (48, 33)};
//   (48.25, 33.3) @TEXT("AVDD18_S", size=0.6, rotate=90, halign="start");
//   %g9 = $GROUND @ATTACH &0 => @PLACE(48, 25.5);
//   &0 @WIRE {#VAVDD18:2 %g9:p};
//   &AVDD18_S @WIRE {#IMAVDD18:P (60, 37)};
//   (60.25, 37.3) @TEXT("AVDD18_S", size=0.6, rotate=90, halign="start");
//   &AVDD18 @WIRE {#IMAVDD18:N (60, 25)};
//   (60.25, 24.7) @TEXT("AVDD18", size=0.6, rotate=90, halign="end");
//   (-30, 43) @TEXT("tb_top_sine: full ADC, coherent differential sine from 50 ohm per side", halign="start") => @SET-STYLE $title_style;
//   (-30, 41.4) @TEXT("capture.txt: D13..D0 and CLK-fall -> RDY time per conversion; power.txt: average supply currents", halign="start") => @SET-STYLE $note_style
// }
