// tb_cdac_settle: DAC step settling, conversion start, hold droop, VREFP charge
// @RNL(type="header") {
//   @VERSION("0.3");
//   @USE-PACKAGE(name="adc28", version="0.1", path="../../design/rnl/adc28.rnl")
// }
// generated by `python -m adcflow gen` from specs/ -- do not edit (tools/adcflow/gen_tb.py)
// Globals vdd, vdd18, tempc, noise_en, devnoise, beh_speed, vref_in come from the run deck.
simulator lang=spectre
parameters tper=10n ctop=15f
parameters tstop=7*tper
// DH5 of the DUT is driven by VDH5 (AC source for the control input capacitance)
XDUT (VIN VG TOP VCM VREFP 0 PHI_S PHI_SB CONV DH12 DH11 DH10 DH9 DH8 DH7 DH6 DH5X DH4 DH3 \
        DH2 DH1 DH0 RL12 RL11 RL10 RL9 RL8 RL7 RL6 RL5 RL4 RL3 RL2 RL1 RL0 VDDA 0) adc_cdac
VVIN (VIN 0) vsource dc=0.45
VDH5 (DH5X 0) vsource dc=0 mag=1
CTOP (TOP 0) capacitor c=ctop
IBS (VIN PHI_B PHI_BB VG VDDA 0) adc_bootstrap_va kboost=1
// conv 3: RL12, conv 4: RL5, conv 5: RL0 at 1 ns; conv 6: RL12..RL0 every 150 ps
ISEQ (CONV DH12 DH11 DH10 DH9 DH8 DH7 DH6 DH5 DH4 DH3 DH2 DH1 DH0 RL12 RL11 RL10 RL9 RL8 RL7 \
        RL6 RL5 RL4 RL3 RL2 RL1 RL0 VDDA 0) tb_cdac_seq_va mode=1 n0=3 sel0=1 sel1=15 sel2=25
VREFP (VREFP_S 0) vsource dc=vref_in
// VREFP charge over cycle 6 (track + full conversion)
IMREF (VREFP_S VREFP) tb_imeter_va tstart=5n*11-0.2n tstop=5n*13-0.2n label="VREFP" fname="qref.txt"
VCLK (CLK 0) vsource type=pulse val0=0 val1=vdd period=tper width=tper/2-20p rise=20p fall=20p
// ideal sampling phases
ICG (CLK PHI_S PHI_SB PHI_B PHI_BB CONV VDDA 0) adc_clkgen_va
VDDA (VDDA 0) vsource dc=vdd
VVCM (VCM 0) vsource dc=vref_in/2
tran1 tran stop=tstop maxstep=2p
ac1 ac freq=100M
save TOP CONV VDH5:p
// @RNL {
//   /* --- semantics --- */
//   &0 @ADD-TO $GROUND_NET_SET;
//   #XDUT @PLACE(11, 0);
//   #VVIN @PLACE(-16, 8);
//   #VDH5 @PLACE(-16, -1);
//   #VCLK @PLACE(-16, -10);
//   #IBS @PLACE(44, 3);
//   #ISEQ @PLACE(44, -17);
//   #ICG @PLACE(44, -39);
//   #CTOP @PLACE(0, -18);
//   #VREFP @PLACE(0, 20);
//   #IMREF @PLACE(12, 21);
//   #VDDA @PLACE(24, 20);
//   #VVCM @PLACE(36, 20);
//   &VIN @WIRE {#XDUT:VIN (-2, 4)};
//   (-2.3, 3.75) @TEXT("VIN", size=0.6, halign="end");
//   &VG @WIRE {#XDUT:VG (-2, -4)};
//   (-2.3, -4.25) @TEXT("VG", size=0.6, halign="end");
//   &TOP @WIRE {#XDUT:TOP (24, 5)};
//   (24.3, 4.75) @TEXT("TOP", size=0.6, halign="start");
//   &VCM @WIRE {#XDUT:VCM (6, 10)};
//   (6.25, 10.3) @TEXT("VCM", size=0.6, rotate=90, halign="start");
//   &VREFP @WIRE {#XDUT:VREFP (10, 10)};
//   (10.25, 10.3) @TEXT("VREFP", size=0.6, rotate=90, halign="start");
//   %g1 = $GROUND @ATTACH &0 => @PLACE(15.5, 9);
//   &0 @WIRE {#XDUT:VREFN (14, 9) (15.5, 9) %g1:p};
//   &PHI_S @WIRE {#XDUT:PHI_S (-2, 2)};
//   (-2.3, 1.75) @TEXT("PHI_S", size=0.6, halign="end");
//   &PHI_SB @WIRE {#XDUT:PHI_SB (-2, 0)};
//   (-2.3, -0.25) @TEXT("PHI_SB", size=0.6, halign="end");
//   &CONV @WIRE {#XDUT:CONV (-2, -2)};
//   (-2.3, -2.25) @TEXT("CONV", size=0.6, halign="end");
//   {&DH12 &DH11 &DH10 &DH9 &DH8 &DH7 &DH6 &DH5X &DH4 &DH3 &DH2 &DH1 &DH0} @WIRE {#XDUT:DH12 (7, -10)};
//   (7.25, -10.3) @TEXT("DH<12:0>", size=0.6, rotate=90, halign="end");
//   {&RL12 &RL11 &RL10 &RL9 &RL8 &RL7 &RL6 &RL5 &RL4 &RL3 &RL2 &RL1 &RL0} @WIRE {#XDUT:RL12 (13, -10)};
//   (13.25, -10.3) @TEXT("RL<12:0>", size=0.6, rotate=90, halign="end");
//   &VDDA @WIRE {#XDUT:DVDD (24, 0)};
//   (24.3, -0.25) @TEXT("VDDA", size=0.6, halign="start");
//   %g2 = $GROUND @ATTACH &0 => @PLACE(23.5, -4);
//   &0 @WIRE {#XDUT:VSS (23.5, -4) (23.5, -4) %g2:p};
//   &VIN @WIRE {#VVIN:1 (-16, 12)};
//   (-15.75, 12.3) @TEXT("VIN", size=0.6, rotate=90, halign="start");
//   %g3 = $GROUND @ATTACH &0 => @PLACE(-16, 4.5);
//   &0 @WIRE {#VVIN:2 %g3:p};
//   &DH5X @WIRE {#VDH5:1 (-16, 3)};
//   (-15.75, 3.3) @TEXT("DH5X", size=0.6, rotate=90, halign="start");
//   %g4 = $GROUND @ATTACH &0 => @PLACE(-16, -4.5);
//   &0 @WIRE {#VDH5:2 %g4:p};
//   &TOP @WIRE {#CTOP:1 (0, -14)};
//   (0.25, -13.7) @TEXT("TOP", size=0.6, rotate=90, halign="start");
//   %g5 = $GROUND @ATTACH &0 => @PLACE(0, -21.5);
//   &0 @WIRE {#CTOP:2 %g5:p};
//   &VIN @WIRE {#IBS:VIN (36, 5)};
//   (35.7, 4.75) @TEXT("VIN", size=0.6, halign="end");
//   &PHI_B @WIRE {#IBS:PHI_B (36, 3)};
//   (35.7, 2.75) @TEXT("PHI_B", size=0.6, halign="end");
//   &PHI_BB @WIRE {#IBS:PHI_BB (36, 1)};
//   (35.7, 0.75) @TEXT("PHI_BB", size=0.6, halign="end");
//   &VG @WIRE {#IBS:VG (52, 5)};
//   (52.3, 4.75) @TEXT("VG", size=0.6, halign="start");
//   &VDDA @WIRE {#IBS:AVDD (44, 10)};
//   (44.25, 10.3) @TEXT("VDDA", size=0.6, rotate=90, halign="start");
//   %g6 = $GROUND @ATTACH &0 => @PLACE(48, -3.5);
//   &0 @WIRE {#IBS:VSS %g6:p};
//   &CONV @WIRE {#ISEQ:CONV (36, -17)};
//   (35.7, -17.25) @TEXT("CONV", size=0.6, halign="end");
//   {&DH12 &DH11 &DH10 &DH9 &DH8 &DH7 &DH6 &DH5 &DH4 &DH3 &DH2 &DH1 &DH0} @WIRE {#ISEQ:DH12 (53, -15)};
//   (53.3, -15.25) @TEXT("DH<12:0>", size=0.6, halign="start");
//   {&RL12 &RL11 &RL10 &RL9 &RL8 &RL7 &RL6 &RL5 &RL4 &RL3 &RL2 &RL1 &RL0} @WIRE {#ISEQ:RL12 (53, -19)};
//   (53.3, -19.25) @TEXT("RL<12:0>", size=0.6, halign="start");
//   &VDDA @WIRE {#ISEQ:VDD (44, -10)};
//   (44.25, -9.7) @TEXT("VDDA", size=0.6, rotate=90, halign="start");
//   %g7 = $GROUND @ATTACH &0 => @PLACE(44, -23.5);
//   &0 @WIRE {#ISEQ:VSS %g7:p};
//   &VREFP_S @WIRE {#VREFP:1 (0, 24)};
//   (0.25, 24.3) @TEXT("VREFP_S", size=0.6, rotate=90, halign="start");
//   %g8 = $GROUND @ATTACH &0 => @PLACE(0, 16.5);
//   &0 @WIRE {#VREFP:2 %g8:p};
//   &VREFP_S @WIRE {#IMREF:P (12, 26)};
//   (12.25, 26.3) @TEXT("VREFP_S", size=0.6, rotate=90, halign="start");
//   &VREFP @WIRE {#IMREF:N (12, 16)};
//   (12.25, 15.7) @TEXT("VREFP", size=0.6, rotate=90, halign="end");
//   &CLK @WIRE {#VCLK:1 (-16, -6)};
//   (-15.75, -5.7) @TEXT("CLK", size=0.6, rotate=90, halign="start");
//   %g9 = $GROUND @ATTACH &0 => @PLACE(-16, -13.5);
//   &0 @WIRE {#VCLK:2 %g9:p};
//   &CLK @WIRE {#ICG:CLK (36, -39)};
//   (35.7, -39.25) @TEXT("CLK", size=0.6, halign="end");
//   &PHI_S @WIRE {#ICG:PHI_S (52, -35)};
//   (52.3, -35.25) @TEXT("PHI_S", size=0.6, halign="start");
//   &PHI_SB @WIRE {#ICG:PHI_SB (52, -37)};
//   (52.3, -37.25) @TEXT("PHI_SB", size=0.6, halign="start");
//   &PHI_B @WIRE {#ICG:PHI_B (52, -39)};
//   (52.3, -39.25) @TEXT("PHI_B", size=0.6, halign="start");
//   &PHI_BB @WIRE {#ICG:PHI_BB (52, -41)};
//   (52.3, -41.25) @TEXT("PHI_BB", size=0.6, halign="start");
//   &CONV @WIRE {#ICG:CONV (52, -43)};
//   (52.3, -43.25) @TEXT("CONV", size=0.6, halign="start");
//   &VDDA @WIRE {#ICG:AVDD (44, -30)};
//   (44.25, -29.7) @TEXT("VDDA", size=0.6, rotate=90, halign="start");
//   %g10 = $GROUND @ATTACH &0 => @PLACE(44, -47.5);
//   &0 @WIRE {#ICG:VSS %g10:p};
//   &VDDA @WIRE {#VDDA:1 (24, 24)};
//   (24.25, 24.3) @TEXT("VDDA", size=0.6, rotate=90, halign="start");
//   %g11 = $GROUND @ATTACH &0 => @PLACE(24, 16.5);
//   &0 @WIRE {#VDDA:2 %g11:p};
//   &VCM @WIRE {#VVCM:1 (36, 24)};
//   (36.25, 24.3) @TEXT("VCM", size=0.6, rotate=90, halign="start");
//   %g12 = $GROUND @ATTACH &0 => @PLACE(36, 16.5);
//   &0 @WIRE {#VVCM:2 %g12:p};
//   (-30, 34) @TEXT("tb_cdac_settle: DAC step settling, conversion start, hold droop, VREFP charge", halign="start") => @SET-STYLE $title_style;
//   (-30, 32.4) @TEXT("cycle 1 has no control activity: conversion-start settling and 5 ns hold droop", halign="start") => @SET-STYLE $note_style
// }
