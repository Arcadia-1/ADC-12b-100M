// tb_cdac_weights: input gain, sampling capacitance and the 26 half weights
// @RNL(type="header") {
//   @VERSION("0.3");
//   @USE-PACKAGE(name="adc28", version="0.1", path="../../design/rnl/adc28.rnl")
// }
// generated by `python -m adcflow gen` from specs/ -- do not edit (tools/adcflow/gen_tb.py)
// Globals vdd, vdd18, tempc, noise_en, devnoise, beh_speed, vref_in come from the run deck.
simulator lang=spectre
parameters tper=10n ctop=15f
parameters tstop=29*tper+1n
XDUT (VIN VG TOP VCM VREFP 0 PHI_S PHI_SB CONV DH12 DH11 DH10 DH9 DH8 DH7 DH6 DH5 DH4 DH3 \
        DH2 DH1 DH0 RL12 RL11 RL10 RL9 RL8 RL7 RL6 RL5 RL4 RL3 RL2 RL1 RL0 VDDA 0) adc_cdac
// 0.65 V (conv 1), 0.25 V (conv 2), 0.25 -> 0.65 V step while tracking in cycle 3, then 0.45 V
VVIN (VIN 0) vsource type=pwl wave=[0.0000e+00 0.65 9.9000e-09 0.65 1.0000e-08 0.25 2.2000e-08 0.25 2.2010e-08 0.65 2.7000e-08 0.65 2.7010e-08 0.45]
CTOP (TOP 0) capacitor c=ctop
// ideal bootstrap
IBS (VIN PHI_B PHI_BB VG VDDA 0) adc_bootstrap_va kboost=1
ISEQ (CONV DH12 DH11 DH10 DH9 DH8 DH7 DH6 DH5 DH4 DH3 DH2 DH1 DH0 RL12 RL11 RL10 RL9 RL8 RL7 \
        RL6 RL5 RL4 RL3 RL2 RL1 RL0 VDDA 0) tb_cdac_seq_va mode=0 n0=4
ISP1 (TOP 0 CONV 0) tb_sampler_va dir=1 delay=0.9n fname="s_pre.txt"
ISP2 (TOP 0 CONV 0) tb_sampler_va dir=1 delay=2.2n fname="s_hold.txt"
VVCM (VCM_S 0) vsource dc=vref_in/2
// charge into the top plate for the VIN step while tracking = C_S * 0.4 V
IMVCM (VCM_S VCM) tb_imeter_va tstart=21.5n tstop=24.5n label="VCM" fname="qcm.txt"
VCLK (CLK 0) vsource type=pulse val0=0 val1=vdd period=tper width=tper/2-20p rise=20p fall=20p
// ideal sampling phases
ICG (CLK PHI_S PHI_SB PHI_B PHI_BB CONV VDDA 0) adc_clkgen_va
VDDA (VDDA 0) vsource dc=vdd
VREFP (VREFP 0) vsource dc=vref_in
tran1 tran stop=tstop outputstart=tstop
tbopts options save=none
// @RNL {
//   /* --- semantics --- */
//   &0 @ADD-TO $GROUND_NET_SET;
//   #XDUT @PLACE(30, 0);
//   #VVIN @PLACE(-16, 7);
//   #VCLK @PLACE(-16, -2);
//   #IBS @PLACE(83, 2);
//   #ISEQ @PLACE(83, -41);
//   #ISP1 @PLACE(83, -80);
//   #ISP2 @PLACE(83, -95);
//   #ICG @PLACE(83, -116);
//   #CTOP @PLACE(0, -17);
//   #VVCM @PLACE(0, 19);
//   #IMVCM @PLACE(12, 21);
//   #VDDA @PLACE(24, 19);
//   #VREFP @PLACE(36, 19);
//   &VIN @WIRE {#XDUT:VIN (-2, 4)};
//   (-2.3, 3.75) @TEXT("VIN", size=0.6, halign="end");
//   &VG @WIRE {#XDUT:VG (-2, 2)};
//   (-2.3, 1.75) @TEXT("VG", size=0.6, halign="end");
//   &TOP @WIRE {#XDUT:TOP (62, 0)};
//   (62.3, -0.25) @TEXT("TOP", size=0.6, halign="start");
//   &VCM @WIRE {#XDUT:VCM (28, 9)};
//   (28.25, 9.3) @TEXT("VCM", size=0.6, rotate=90, halign="start");
//   &VREFP @WIRE {#XDUT:VREFP (30, 9)};
//   (30.25, 9.3) @TEXT("VREFP", size=0.6, rotate=90, halign="start");
//   %g1 = $GROUND @ATTACH &0 => @PLACE(3, -8.5);
//   &0 @WIRE {#XDUT:VREFN %g1:p};
//   &PHI_S @WIRE {#XDUT:PHI_S (-2, 0)};
//   (-2.3, -0.25) @TEXT("PHI_S", size=0.6, halign="end");
//   &PHI_SB @WIRE {#XDUT:PHI_SB (-2, -2)};
//   (-2.3, -2.25) @TEXT("PHI_SB", size=0.6, halign="end");
//   &CONV @WIRE {#XDUT:CONV (-2, -4)};
//   (-2.3, -4.25) @TEXT("CONV", size=0.6, halign="end");
//   &DH12 @WIRE {#XDUT:DH12 (5, -9)};
//   (5.25, -9.3) @TEXT("DH12", size=0.6, rotate=90, halign="end");
//   &DH11 @WIRE {#XDUT:DH11 (7, -9)};
//   (7.25, -9.3) @TEXT("DH11", size=0.6, rotate=90, halign="end");
//   &DH10 @WIRE {#XDUT:DH10 (9, -9)};
//   (9.25, -9.3) @TEXT("DH10", size=0.6, rotate=90, halign="end");
//   &DH9 @WIRE {#XDUT:DH9 (11, -9)};
//   (11.25, -9.3) @TEXT("DH9", size=0.6, rotate=90, halign="end");
//   &DH8 @WIRE {#XDUT:DH8 (13, -9)};
//   (13.25, -9.3) @TEXT("DH8", size=0.6, rotate=90, halign="end");
//   &DH7 @WIRE {#XDUT:DH7 (15, -9)};
//   (15.25, -9.3) @TEXT("DH7", size=0.6, rotate=90, halign="end");
//   &DH6 @WIRE {#XDUT:DH6 (17, -9)};
//   (17.25, -9.3) @TEXT("DH6", size=0.6, rotate=90, halign="end");
//   &DH5 @WIRE {#XDUT:DH5 (19, -9)};
//   (19.25, -9.3) @TEXT("DH5", size=0.6, rotate=90, halign="end");
//   &DH4 @WIRE {#XDUT:DH4 (21, -9)};
//   (21.25, -9.3) @TEXT("DH4", size=0.6, rotate=90, halign="end");
//   &DH3 @WIRE {#XDUT:DH3 (23, -9)};
//   (23.25, -9.3) @TEXT("DH3", size=0.6, rotate=90, halign="end");
//   &DH2 @WIRE {#XDUT:DH2 (25, -9)};
//   (25.25, -9.3) @TEXT("DH2", size=0.6, rotate=90, halign="end");
//   &DH1 @WIRE {#XDUT:DH1 (27, -9)};
//   (27.25, -9.3) @TEXT("DH1", size=0.6, rotate=90, halign="end");
//   &DH0 @WIRE {#XDUT:DH0 (29, -9)};
//   (29.25, -9.3) @TEXT("DH0", size=0.6, rotate=90, halign="end");
//   &RL12 @WIRE {#XDUT:RL12 (31, -9)};
//   (31.25, -9.3) @TEXT("RL12", size=0.6, rotate=90, halign="end");
//   &RL11 @WIRE {#XDUT:RL11 (33, -9)};
//   (33.25, -9.3) @TEXT("RL11", size=0.6, rotate=90, halign="end");
//   &RL10 @WIRE {#XDUT:RL10 (35, -9)};
//   (35.25, -9.3) @TEXT("RL10", size=0.6, rotate=90, halign="end");
//   &RL9 @WIRE {#XDUT:RL9 (37, -9)};
//   (37.25, -9.3) @TEXT("RL9", size=0.6, rotate=90, halign="end");
//   &RL8 @WIRE {#XDUT:RL8 (39, -9)};
//   (39.25, -9.3) @TEXT("RL8", size=0.6, rotate=90, halign="end");
//   &RL7 @WIRE {#XDUT:RL7 (41, -9)};
//   (41.25, -9.3) @TEXT("RL7", size=0.6, rotate=90, halign="end");
//   &RL6 @WIRE {#XDUT:RL6 (43, -9)};
//   (43.25, -9.3) @TEXT("RL6", size=0.6, rotate=90, halign="end");
//   &RL5 @WIRE {#XDUT:RL5 (45, -9)};
//   (45.25, -9.3) @TEXT("RL5", size=0.6, rotate=90, halign="end");
//   &RL4 @WIRE {#XDUT:RL4 (47, -9)};
//   (47.25, -9.3) @TEXT("RL4", size=0.6, rotate=90, halign="end");
//   &RL3 @WIRE {#XDUT:RL3 (49, -9)};
//   (49.25, -9.3) @TEXT("RL3", size=0.6, rotate=90, halign="end");
//   &RL2 @WIRE {#XDUT:RL2 (51, -9)};
//   (51.25, -9.3) @TEXT("RL2", size=0.6, rotate=90, halign="end");
//   &RL1 @WIRE {#XDUT:RL1 (53, -9)};
//   (53.25, -9.3) @TEXT("RL1", size=0.6, rotate=90, halign="end");
//   &RL0 @WIRE {#XDUT:RL0 (55, -9)};
//   (55.25, -9.3) @TEXT("RL0", size=0.6, rotate=90, halign="end");
//   &VDDA @WIRE {#XDUT:DVDD (32, 9)};
//   (32.25, 9.3) @TEXT("VDDA", size=0.6, rotate=90, halign="start");
//   %g2 = $GROUND @ATTACH &0 => @PLACE(57, -8.5);
//   &0 @WIRE {#XDUT:VSS %g2:p};
//   &VIN @WIRE {#VVIN:1 (-16, 11)};
//   (-15.75, 11.3) @TEXT("VIN", size=0.6, rotate=90, halign="start");
//   %g3 = $GROUND @ATTACH &0 => @PLACE(-16, 3.5);
//   &0 @WIRE {#VVIN:2 %g3:p};
//   &TOP @WIRE {#CTOP:1 (0, -13)};
//   (0.25, -12.7) @TEXT("TOP", size=0.6, rotate=90, halign="start");
//   %g4 = $GROUND @ATTACH &0 => @PLACE(0, -20.5);
//   &0 @WIRE {#CTOP:2 %g4:p};
//   &VIN @WIRE {#IBS:VIN (74, 4)};
//   (73.7, 3.75) @TEXT("VIN", size=0.6, halign="end");
//   &PHI_B @WIRE {#IBS:PHI_B (74, 2)};
//   (73.7, 1.75) @TEXT("PHI_B", size=0.6, halign="end");
//   &PHI_BB @WIRE {#IBS:PHI_BB (74, 0)};
//   (73.7, -0.25) @TEXT("PHI_BB", size=0.6, halign="end");
//   &VG @WIRE {#IBS:VG (92, 2)};
//   (92.3, 1.75) @TEXT("VG", size=0.6, halign="start");
//   &VDDA @WIRE {#IBS:AVDD (83, 9)};
//   (83.25, 9.3) @TEXT("VDDA", size=0.6, rotate=90, halign="start");
//   %g5 = $GROUND @ATTACH &0 => @PLACE(83, -4.5);
//   &0 @WIRE {#IBS:VSS %g5:p};
//   &CONV @WIRE {#ISEQ:CONV (74, -41)};
//   (73.7, -41.25) @TEXT("CONV", size=0.6, halign="end");
//   &DH12 @WIRE {#ISEQ:DH12 (92, -16)};
//   (92.3, -16.25) @TEXT("DH12", size=0.6, halign="start");
//   &DH11 @WIRE {#ISEQ:DH11 (92, -18)};
//   (92.3, -18.25) @TEXT("DH11", size=0.6, halign="start");
//   &DH10 @WIRE {#ISEQ:DH10 (92, -20)};
//   (92.3, -20.25) @TEXT("DH10", size=0.6, halign="start");
//   &DH9 @WIRE {#ISEQ:DH9 (92, -22)};
//   (92.3, -22.25) @TEXT("DH9", size=0.6, halign="start");
//   &DH8 @WIRE {#ISEQ:DH8 (92, -24)};
//   (92.3, -24.25) @TEXT("DH8", size=0.6, halign="start");
//   &DH7 @WIRE {#ISEQ:DH7 (92, -26)};
//   (92.3, -26.25) @TEXT("DH7", size=0.6, halign="start");
//   &DH6 @WIRE {#ISEQ:DH6 (92, -28)};
//   (92.3, -28.25) @TEXT("DH6", size=0.6, halign="start");
//   &DH5 @WIRE {#ISEQ:DH5 (92, -30)};
//   (92.3, -30.25) @TEXT("DH5", size=0.6, halign="start");
//   &DH4 @WIRE {#ISEQ:DH4 (92, -32)};
//   (92.3, -32.25) @TEXT("DH4", size=0.6, halign="start");
//   &DH3 @WIRE {#ISEQ:DH3 (92, -34)};
//   (92.3, -34.25) @TEXT("DH3", size=0.6, halign="start");
//   &DH2 @WIRE {#ISEQ:DH2 (92, -36)};
//   (92.3, -36.25) @TEXT("DH2", size=0.6, halign="start");
//   &DH1 @WIRE {#ISEQ:DH1 (92, -38)};
//   (92.3, -38.25) @TEXT("DH1", size=0.6, halign="start");
//   &DH0 @WIRE {#ISEQ:DH0 (92, -40)};
//   (92.3, -40.25) @TEXT("DH0", size=0.6, halign="start");
//   &RL12 @WIRE {#ISEQ:RL12 (92, -42)};
//   (92.3, -42.25) @TEXT("RL12", size=0.6, halign="start");
//   &RL11 @WIRE {#ISEQ:RL11 (92, -44)};
//   (92.3, -44.25) @TEXT("RL11", size=0.6, halign="start");
//   &RL10 @WIRE {#ISEQ:RL10 (92, -46)};
//   (92.3, -46.25) @TEXT("RL10", size=0.6, halign="start");
//   &RL9 @WIRE {#ISEQ:RL9 (92, -48)};
//   (92.3, -48.25) @TEXT("RL9", size=0.6, halign="start");
//   &RL8 @WIRE {#ISEQ:RL8 (92, -50)};
//   (92.3, -50.25) @TEXT("RL8", size=0.6, halign="start");
//   &RL7 @WIRE {#ISEQ:RL7 (92, -52)};
//   (92.3, -52.25) @TEXT("RL7", size=0.6, halign="start");
//   &RL6 @WIRE {#ISEQ:RL6 (92, -54)};
//   (92.3, -54.25) @TEXT("RL6", size=0.6, halign="start");
//   &RL5 @WIRE {#ISEQ:RL5 (92, -56)};
//   (92.3, -56.25) @TEXT("RL5", size=0.6, halign="start");
//   &RL4 @WIRE {#ISEQ:RL4 (92, -58)};
//   (92.3, -58.25) @TEXT("RL4", size=0.6, halign="start");
//   &RL3 @WIRE {#ISEQ:RL3 (92, -60)};
//   (92.3, -60.25) @TEXT("RL3", size=0.6, halign="start");
//   &RL2 @WIRE {#ISEQ:RL2 (92, -62)};
//   (92.3, -62.25) @TEXT("RL2", size=0.6, halign="start");
//   &RL1 @WIRE {#ISEQ:RL1 (92, -64)};
//   (92.3, -64.25) @TEXT("RL1", size=0.6, halign="start");
//   &RL0 @WIRE {#ISEQ:RL0 (92, -66)};
//   (92.3, -66.25) @TEXT("RL0", size=0.6, halign="start");
//   &VDDA @WIRE {#ISEQ:VDD (83, -11)};
//   (83.25, -10.7) @TEXT("VDDA", size=0.6, rotate=90, halign="start");
//   %g6 = $GROUND @ATTACH &0 => @PLACE(83, -70.5);
//   &0 @WIRE {#ISEQ:VSS %g6:p};
//   &TOP @WIRE {#ISP1:P (74, -79)};
//   (73.7, -79.25) @TEXT("TOP", size=0.6, halign="end");
//   %g7 = $GROUND @ATTACH &0 => @PLACE(74.5, -81);
//   &0 @WIRE {#ISP1:N (74.5, -81) (74.5, -81) %g7:p};
//   &CONV @WIRE {#ISP1:TRIG (81, -86)};
//   (81.25, -86.3) @TEXT("CONV", size=0.6, rotate=90, halign="end");
//   %g8 = $GROUND @ATTACH &0 => @PLACE(85, -85.5);
//   &0 @WIRE {#ISP1:VSS %g8:p};
//   &TOP @WIRE {#ISP2:P (74, -94)};
//   (73.7, -94.25) @TEXT("TOP", size=0.6, halign="end");
//   %g9 = $GROUND @ATTACH &0 => @PLACE(74.5, -96);
//   &0 @WIRE {#ISP2:N (74.5, -96) (74.5, -96) %g9:p};
//   &CONV @WIRE {#ISP2:TRIG (81, -101)};
//   (81.25, -101.3) @TEXT("CONV", size=0.6, rotate=90, halign="end");
//   %g10 = $GROUND @ATTACH &0 => @PLACE(85, -100.5);
//   &0 @WIRE {#ISP2:VSS %g10:p};
//   &VCM_S @WIRE {#VVCM:1 (0, 23)};
//   (0.25, 23.3) @TEXT("VCM_S", size=0.6, rotate=90, halign="start");
//   %g11 = $GROUND @ATTACH &0 => @PLACE(0, 15.5);
//   &0 @WIRE {#VVCM:2 %g11:p};
//   &VCM_S @WIRE {#IMVCM:P (12, 27)};
//   (12.25, 27.3) @TEXT("VCM_S", size=0.6, rotate=90, halign="start");
//   &VCM @WIRE {#IMVCM:N (12, 15)};
//   (12.25, 14.7) @TEXT("VCM", size=0.6, rotate=90, halign="end");
//   &CLK @WIRE {#VCLK:1 (-16, 2)};
//   (-15.75, 2.3) @TEXT("CLK", size=0.6, rotate=90, halign="start");
//   %g12 = $GROUND @ATTACH &0 => @PLACE(-16, -5.5);
//   &0 @WIRE {#VCLK:2 %g12:p};
//   &CLK @WIRE {#ICG:CLK (74, -116)};
//   (73.7, -116.25) @TEXT("CLK", size=0.6, halign="end");
//   &PHI_S @WIRE {#ICG:PHI_S (92, -112)};
//   (92.3, -112.25) @TEXT("PHI_S", size=0.6, halign="start");
//   &PHI_SB @WIRE {#ICG:PHI_SB (92, -114)};
//   (92.3, -114.25) @TEXT("PHI_SB", size=0.6, halign="start");
//   &PHI_B @WIRE {#ICG:PHI_B (92, -116)};
//   (92.3, -116.25) @TEXT("PHI_B", size=0.6, halign="start");
//   &PHI_BB @WIRE {#ICG:PHI_BB (92, -118)};
//   (92.3, -118.25) @TEXT("PHI_BB", size=0.6, halign="start");
//   &CONV @WIRE {#ICG:CONV (92, -120)};
//   (92.3, -120.25) @TEXT("CONV", size=0.6, halign="start");
//   &VDDA @WIRE {#ICG:AVDD (83, -107)};
//   (83.25, -106.7) @TEXT("VDDA", size=0.6, rotate=90, halign="start");
//   %g13 = $GROUND @ATTACH &0 => @PLACE(83, -124.5);
//   &0 @WIRE {#ICG:VSS %g13:p};
//   &VDDA @WIRE {#VDDA:1 (24, 23)};
//   (24.25, 23.3) @TEXT("VDDA", size=0.6, rotate=90, halign="start");
//   %g14 = $GROUND @ATTACH &0 => @PLACE(24, 15.5);
//   &0 @WIRE {#VDDA:2 %g14:p};
//   &VREFP @WIRE {#VREFP:1 (36, 23)};
//   (36.25, 23.3) @TEXT("VREFP", size=0.6, rotate=90, halign="start");
//   %g15 = $GROUND @ATTACH &0 => @PLACE(36, 15.5);
//   &0 @WIRE {#VREFP:2 %g15:p};
//   (-30, 33) @TEXT("tb_cdac_weights: input gain, sampling capacitance and the 26 half weights", halign="start") => @SET-STYLE $title_style;
//   (-30, 31.4) @TEXT("conversions 4..29 raise one control line each (DH12, RL12, ..., DH0, RL0) for 1.5 ns", halign="start") => @SET-STYLE $note_style;
//   (-30, 29.8) @TEXT("top plate sampled 0.9 ns and 2.2 ns after CONV rises; weight = step / input gain", halign="start") => @SET-STYLE $note_style
// }
