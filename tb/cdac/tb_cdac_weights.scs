// tb_cdac_weights: input gain, sampling capacitance and the 26 half weights
// @RNL(type="header") {
//   @VERSION("0.3");
//   @USE-PACKAGE(name="adc28", version="0.1", path="../../design/rnl/adc28.rnl")
// }
// generated by `python -m adcflow gen` from specs/ -- do not edit (tools/adcflow/gen_tb.py)
// Globals vdd, vdd18, tempc, noise_en, devnoise, beh_speed, vref_in come from the run deck.
simulator lang=spectre
parameters tper=10n ctop=15f
parameters tstop=29*tper+1n
XDUT (VIN VG TOP VCM VREFP 0 PHI_S PHI_SB CONV DH12 DH11 DH10 DH9 DH8 DH7 DH6 DH5 DH4 DH3 \
        DH2 DH1 DH0 RL12 RL11 RL10 RL9 RL8 RL7 RL6 RL5 RL4 RL3 RL2 RL1 RL0 VDDA 0) adc_cdac
// 0.65 V (conv 1), 0.25 V (conv 2), 0.25 -> 0.65 V step while tracking in cycle 3, then 0.45 V
VVIN (VIN 0) vsource type=pwl wave=[0.0000e+00 0.65 9.9000e-09 0.65 1.0000e-08 0.25 2.2000e-08 0.25 2.2010e-08 0.65 2.7000e-08 0.65 2.7010e-08 0.45]
CTOP (TOP 0) capacitor c=ctop
// ideal bootstrap
IBS (VIN PHI_B PHI_BB VG VDDA 0) adc_bootstrap_va kboost=1
ISEQ (CONV DH12 DH11 DH10 DH9 DH8 DH7 DH6 DH5 DH4 DH3 DH2 DH1 DH0 RL12 RL11 RL10 RL9 RL8 RL7 \
        RL6 RL5 RL4 RL3 RL2 RL1 RL0 VDDA 0) tb_cdac_seq_va mode=0 n0=4
ISP1 (TOP 0 CONV 0) tb_sampler_va dir=1 delay=0.9n fname="s_pre.txt"
ISP2 (TOP 0 CONV 0) tb_sampler_va dir=1 delay=2.2n fname="s_hold.txt"
VVCM (VCM_S 0) vsource dc=vref_in/2
// charge into the top plate for the VIN step while tracking = C_S * 0.4 V
IMVCM (VCM_S VCM) tb_imeter_va tstart=21.5n tstop=24.5n label="VCM" fname="qcm.txt"
VCLK (CLK 0) vsource type=pulse val0=0 val1=vdd period=tper width=tper/2-20p rise=20p fall=20p
// ideal sampling phases
ICG (CLK PHI_S PHI_SB PHI_B PHI_BB CONV VDDA 0) adc_clkgen_va
VDDA (VDDA 0) vsource dc=vdd
VREFP (VREFP 0) vsource dc=vref_in
tran1 tran stop=tstop outputstart=tstop
tbopts options save=none
// @RNL {
//   /* --- semantics --- */
//   &0 @ADD-TO $GROUND_NET_SET;
//   #XDUT @PLACE(11, 0);
//   #VVIN @PLACE(-16, 8);
//   #VCLK @PLACE(-16, -1);
//   #IBS @PLACE(44, 3);
//   #ISEQ @PLACE(44, -17);
//   #ISP1 @PLACE(43, -33);
//   #ISP2 @PLACE(43, -48);
//   #ICG @PLACE(44, -69);
//   #CTOP @PLACE(0, -18);
//   #VVCM @PLACE(0, 20);
//   #IMVCM @PLACE(12, 21);
//   #VDDA @PLACE(24, 20);
//   #VREFP @PLACE(36, 20);
//   &VIN @WIRE {#XDUT:VIN (-2, 4)};
//   (-2.3, 3.75) @TEXT("VIN", size=0.6, halign="end");
//   &VG @WIRE {#XDUT:VG (-2, -4)};
//   (-2.3, -4.25) @TEXT("VG", size=0.6, halign="end");
//   &TOP @WIRE {#XDUT:TOP (24, 5)};
//   (24.3, 4.75) @TEXT("TOP", size=0.6, halign="start");
//   &VCM @WIRE {#XDUT:VCM (6, 10)};
//   (6.25, 10.3) @TEXT("VCM", size=0.6, rotate=90, halign="start");
//   &VREFP @WIRE {#XDUT:VREFP (10, 10)};
//   (10.25, 10.3) @TEXT("VREFP", size=0.6, rotate=90, halign="start");
//   %g1 = $GROUND @ATTACH &0 => @PLACE(15.5, 9);
//   &0 @WIRE {#XDUT:VREFN (14, 9) (15.5, 9) %g1:p};
//   &PHI_S @WIRE {#XDUT:PHI_S (-2, 2)};
//   (-2.3, 1.75) @TEXT("PHI_S", size=0.6, halign="end");
//   &PHI_SB @WIRE {#XDUT:PHI_SB (-2, 0)};
//   (-2.3, -0.25) @TEXT("PHI_SB", size=0.6, halign="end");
//   &CONV @WIRE {#XDUT:CONV (-2, -2)};
//   (-2.3, -2.25) @TEXT("CONV", size=0.6, halign="end");
//   {&DH12 &DH11 &DH10 &DH9 &DH8 &DH7 &DH6 &DH5 &DH4 &DH3 &DH2 &DH1 &DH0} @WIRE {#XDUT:DH12 (7, -10)};
//   (7.25, -10.3) @TEXT("DH<12:0>", size=0.6, rotate=90, halign="end");
//   {&RL12 &RL11 &RL10 &RL9 &RL8 &RL7 &RL6 &RL5 &RL4 &RL3 &RL2 &RL1 &RL0} @WIRE {#XDUT:RL12 (13, -10)};
//   (13.25, -10.3) @TEXT("RL<12:0>", size=0.6, rotate=90, halign="end");
//   &VDDA @WIRE {#XDUT:DVDD (24, 0)};
//   (24.3, -0.25) @TEXT("VDDA", size=0.6, halign="start");
//   %g2 = $GROUND @ATTACH &0 => @PLACE(23.5, -4);
//   &0 @WIRE {#XDUT:VSS (23.5, -4) (23.5, -4) %g2:p};
//   &VIN @WIRE {#VVIN:1 (-16, 12)};
//   (-15.75, 12.3) @TEXT("VIN", size=0.6, rotate=90, halign="start");
//   %g3 = $GROUND @ATTACH &0 => @PLACE(-16, 4.5);
//   &0 @WIRE {#VVIN:2 %g3:p};
//   &TOP @WIRE {#CTOP:1 (0, -14)};
//   (0.25, -13.7) @TEXT("TOP", size=0.6, rotate=90, halign="start");
//   %g4 = $GROUND @ATTACH &0 => @PLACE(0, -21.5);
//   &0 @WIRE {#CTOP:2 %g4:p};
//   &VIN @WIRE {#IBS:VIN (36, 5)};
//   (35.7, 4.75) @TEXT("VIN", size=0.6, halign="end");
//   &PHI_B @WIRE {#IBS:PHI_B (36, 3)};
//   (35.7, 2.75) @TEXT("PHI_B", size=0.6, halign="end");
//   &PHI_BB @WIRE {#IBS:PHI_BB (36, 1)};
//   (35.7, 0.75) @TEXT("PHI_BB", size=0.6, halign="end");
//   &VG @WIRE {#IBS:VG (52, 5)};
//   (52.3, 4.75) @TEXT("VG", size=0.6, halign="start");
//   &VDDA @WIRE {#IBS:AVDD (44, 10)};
//   (44.25, 10.3) @TEXT("VDDA", size=0.6, rotate=90, halign="start");
//   %g5 = $GROUND @ATTACH &0 => @PLACE(48, -3.5);
//   &0 @WIRE {#IBS:VSS %g5:p};
//   &CONV @WIRE {#ISEQ:CONV (36, -17)};
//   (35.7, -17.25) @TEXT("CONV", size=0.6, halign="end");
//   {&DH12 &DH11 &DH10 &DH9 &DH8 &DH7 &DH6 &DH5 &DH4 &DH3 &DH2 &DH1 &DH0} @WIRE {#ISEQ:DH12 (53, -15)};
//   (53.3, -15.25) @TEXT("DH<12:0>", size=0.6, halign="start");
//   {&RL12 &RL11 &RL10 &RL9 &RL8 &RL7 &RL6 &RL5 &RL4 &RL3 &RL2 &RL1 &RL0} @WIRE {#ISEQ:RL12 (53, -19)};
//   (53.3, -19.25) @TEXT("RL<12:0>", size=0.6, halign="start");
//   &VDDA @WIRE {#ISEQ:VDD (44, -10)};
//   (44.25, -9.7) @TEXT("VDDA", size=0.6, rotate=90, halign="start");
//   %g6 = $GROUND @ATTACH &0 => @PLACE(44, -23.5);
//   &0 @WIRE {#ISEQ:VSS %g6:p};
//   &TOP @WIRE {#ISP1:P (36, -32)};
//   (35.7, -32.25) @TEXT("TOP", size=0.6, halign="end");
//   %g7 = $GROUND @ATTACH &0 => @PLACE(36.5, -34);
//   &0 @WIRE {#ISP1:N (36.5, -34) (36.5, -34) %g7:p};
//   &CONV @WIRE {#ISP1:TRIG (42, -39)};
//   (42.25, -39.3) @TEXT("CONV", size=0.6, rotate=90, halign="end");
//   %g8 = $GROUND @ATTACH &0 => @PLACE(45, -38.5);
//   &0 @WIRE {#ISP1:VSS %g8:p};
//   &TOP @WIRE {#ISP2:P (36, -47)};
//   (35.7, -47.25) @TEXT("TOP", size=0.6, halign="end");
//   %g9 = $GROUND @ATTACH &0 => @PLACE(36.5, -49);
//   &0 @WIRE {#ISP2:N (36.5, -49) (36.5, -49) %g9:p};
//   &CONV @WIRE {#ISP2:TRIG (42, -54)};
//   (42.25, -54.3) @TEXT("CONV", size=0.6, rotate=90, halign="end");
//   %g10 = $GROUND @ATTACH &0 => @PLACE(45, -53.5);
//   &0 @WIRE {#ISP2:VSS %g10:p};
//   &VCM_S @WIRE {#VVCM:1 (0, 24)};
//   (0.25, 24.3) @TEXT("VCM_S", size=0.6, rotate=90, halign="start");
//   %g11 = $GROUND @ATTACH &0 => @PLACE(0, 16.5);
//   &0 @WIRE {#VVCM:2 %g11:p};
//   &VCM_S @WIRE {#IMVCM:P (12, 26)};
//   (12.25, 26.3) @TEXT("VCM_S", size=0.6, rotate=90, halign="start");
//   &VCM @WIRE {#IMVCM:N (12, 16)};
//   (12.25, 15.7) @TEXT("VCM", size=0.6, rotate=90, halign="end");
//   &CLK @WIRE {#VCLK:1 (-16, 3)};
//   (-15.75, 3.3) @TEXT("CLK", size=0.6, rotate=90, halign="start");
//   %g12 = $GROUND @ATTACH &0 => @PLACE(-16, -4.5);
//   &0 @WIRE {#VCLK:2 %g12:p};
//   &CLK @WIRE {#ICG:CLK (36, -69)};
//   (35.7, -69.25) @TEXT("CLK", size=0.6, halign="end");
//   &PHI_S @WIRE {#ICG:PHI_S (52, -65)};
//   (52.3, -65.25) @TEXT("PHI_S", size=0.6, halign="start");
//   &PHI_SB @WIRE {#ICG:PHI_SB (52, -67)};
//   (52.3, -67.25) @TEXT("PHI_SB", size=0.6, halign="start");
//   &PHI_B @WIRE {#ICG:PHI_B (52, -69)};
//   (52.3, -69.25) @TEXT("PHI_B", size=0.6, halign="start");
//   &PHI_BB @WIRE {#ICG:PHI_BB (52, -71)};
//   (52.3, -71.25) @TEXT("PHI_BB", size=0.6, halign="start");
//   &CONV @WIRE {#ICG:CONV (52, -73)};
//   (52.3, -73.25) @TEXT("CONV", size=0.6, halign="start");
//   &VDDA @WIRE {#ICG:AVDD (44, -60)};
//   (44.25, -59.7) @TEXT("VDDA", size=0.6, rotate=90, halign="start");
//   %g13 = $GROUND @ATTACH &0 => @PLACE(44, -77.5);
//   &0 @WIRE {#ICG:VSS %g13:p};
//   &VDDA @WIRE {#VDDA:1 (24, 24)};
//   (24.25, 24.3) @TEXT("VDDA", size=0.6, rotate=90, halign="start");
//   %g14 = $GROUND @ATTACH &0 => @PLACE(24, 16.5);
//   &0 @WIRE {#VDDA:2 %g14:p};
//   &VREFP @WIRE {#VREFP:1 (36, 24)};
//   (36.25, 24.3) @TEXT("VREFP", size=0.6, rotate=90, halign="start");
//   %g15 = $GROUND @ATTACH &0 => @PLACE(36, 16.5);
//   &0 @WIRE {#VREFP:2 %g15:p};
//   (-30, 34) @TEXT("tb_cdac_weights: input gain, sampling capacitance and the 26 half weights", halign="start") => @SET-STYLE $title_style;
//   (-30, 32.4) @TEXT("conversions 4..29 raise one control line each (DH12, RL12, ..., DH0, RL0) for 1.5 ns", halign="start") => @SET-STYLE $note_style;
//   (-30, 30.8) @TEXT("top plate sampled 0.9 ns and 2.2 ns after CONV rises; weight = step / input gain", halign="start") => @SET-STYLE $note_style
// }
