// tb_cdac_track: sampling-network linearity of the two CDACs from 50 ohm
// @RNL(type="header") {
//   @VERSION("0.3");
//   @USE-PACKAGE(name="adc28", version="0.1", path="../../design/rnl/adc28.rnl")
// }
// generated by `python -m adcflow gen` from specs/ -- do not edit (tools/adcflow/gen_tb.py)
// Globals vdd, vdd18, tempc, noise_en, devnoise, beh_speed, vref_in come from the run deck.
simulator lang=spectre
parameters fin=49.8046875e6 amp_dbfs=-1 npts=256 nskip=4 tper=10n fs_peak=0.9987 vcm_in=0.45 rsrc=50 ctop=15f
parameters amp=fs_peak*pow(10, amp_dbfs/20) tstart=nskip*tper tstop=(nskip+npts+0.5)*tper
XDACP (VINP VGP TOPP VCM VREFP 0 PHI_S PHI_SB CONV LO LO LO LO LO LO LO LO LO LO LO LO LO LO \
        LO LO LO LO LO LO LO LO LO LO LO LO VDDA 0) adc_cdac
XDACN (VINN VGN TOPN VCM VREFP 0 PHI_S PHI_SB CONV LO LO LO LO LO LO LO LO LO LO LO LO LO LO \
        LO LO LO LO LO LO LO LO LO LO LO LO VDDA 0) adc_cdac
VSP (SRCP 0) vsource type=sine sinedc=vcm_in ampl=amp/2 freq=fin
VSN (SRCN 0) vsource type=sine sinedc=vcm_in ampl=-amp/2 freq=fin
RSP (SRCP VINP) resistor r=rsrc
RSN (SRCN VINN) resistor r=rsrc
// all controls low: neutral DAC
VLO (LO 0) vsource dc=0
CTP (TOPP 0) capacitor c=ctop
CTN (TOPN 0) capacitor c=ctop
IBSP (VINP PHI_B PHI_BB VGP VDDA 0) adc_bootstrap_va kboost=1
IBSN (VINN PHI_B PHI_BB VGN VDDA 0) adc_bootstrap_va kboost=1
ISMP (TOPP TOPN CONV 0) tb_sampler_va dir=1 delay=0.3n tstart=tstart fname="samples.txt"
VCLK (CLK 0) vsource type=pulse val0=0 val1=vdd period=tper width=tper/2-20p rise=20p fall=20p
// ideal sampling phases
ICG (CLK PHI_S PHI_SB PHI_B PHI_BB CONV VDDA 0) adc_clkgen_va
VDDA (VDDA 0) vsource dc=vdd
VREFP (VREFP 0) vsource dc=vref_in
VVCM (VCM 0) vsource dc=vref_in/2
tran1 tran stop=tstop outputstart=tstop
tbopts options save=none reltol=1e-5 vabstol=1e-8
// @RNL {
//   /* --- semantics --- */
//   &0 @ADD-TO $GROUND_NET_SET;
//   #XDACP @PLACE(11, 0);
//   #XDACN @PLACE(49, 0);
//   #VSP @PLACE(-16, 8);
//   #VSN @PLACE(-16, -1);
//   #RSP @PLACE(-16, -10);
//   #RSN @PLACE(-16, -19);
//   #VLO @PLACE(-16, -28);
//   #VCLK @PLACE(-16, -37);
//   #IBSP @PLACE(82, 3);
//   #IBSN @PLACE(82, -17);
//   #ISMP @PLACE(81, -33);
//   #ICG @PLACE(82, -54);
//   #CTP @PLACE(0, -18);
//   #CTN @PLACE(8, -18);
//   #VDDA @PLACE(0, 20);
//   #VREFP @PLACE(12, 20);
//   #VVCM @PLACE(24, 20);
//   &VINP @WIRE {#XDACP:VIN (-2, 4)};
//   (-2.3, 3.75) @TEXT("VINP", size=0.6, halign="end");
//   &VGP @WIRE {#XDACP:VG (-2, -4)};
//   (-2.3, -4.25) @TEXT("VGP", size=0.6, halign="end");
//   &TOPP @WIRE {#XDACP:TOP (24, 5)};
//   (24.3, 4.75) @TEXT("TOPP", size=0.6, halign="start");
//   &VCM @WIRE {#XDACP:VCM (6, 10)};
//   (6.25, 10.3) @TEXT("VCM", size=0.6, rotate=90, halign="start");
//   &VREFP @WIRE {#XDACP:VREFP (10, 10)};
//   (10.25, 10.3) @TEXT("VREFP", size=0.6, rotate=90, halign="start");
//   %g1 = $GROUND @ATTACH &0 => @PLACE(15.5, 9);
//   &0 @WIRE {#XDACP:VREFN (14, 9) (15.5, 9) %g1:p};
//   &PHI_S @WIRE {#XDACP:PHI_S (-2, 2)};
//   (-2.3, 1.75) @TEXT("PHI_S", size=0.6, halign="end");
//   &PHI_SB @WIRE {#XDACP:PHI_SB (-2, 0)};
//   (-2.3, -0.25) @TEXT("PHI_SB", size=0.6, halign="end");
//   &CONV @WIRE {#XDACP:CONV (-2, -2)};
//   (-2.3, -2.25) @TEXT("CONV", size=0.6, halign="end");
//   {&LO &LO &LO &LO &LO &LO &LO &LO &LO &LO &LO &LO &LO} @WIRE {#XDACP:DH12 (7, -10)};
//   (7.25, -10.3) @TEXT("LO,LO,LO,LO,LO,LO,LO,LO,LO,LO,LO,LO,LO", size=0.6, rotate=90, halign="end");
//   {&LO &LO &LO &LO &LO &LO &LO &LO &LO &LO &LO &LO &LO} @WIRE {#XDACP:RL12 (13, -10)};
//   (13.25, -10.3) @TEXT("LO,LO,LO,LO,LO,LO,LO,LO,LO,LO,LO,LO,LO", size=0.6, rotate=90, halign="end");
//   &VDDA @WIRE {#XDACP:DVDD (24, 0)};
//   (24.3, -0.25) @TEXT("VDDA", size=0.6, halign="start");
//   %g2 = $GROUND @ATTACH &0 => @PLACE(23.5, -4);
//   &0 @WIRE {#XDACP:VSS (23.5, -4) (23.5, -4) %g2:p};
//   &VINN @WIRE {#XDACN:VIN (36, 4)};
//   (35.7, 3.75) @TEXT("VINN", size=0.6, halign="end");
//   &VGN @WIRE {#XDACN:VG (36, -4)};
//   (35.7, -4.25) @TEXT("VGN", size=0.6, halign="end");
//   &TOPN @WIRE {#XDACN:TOP (62, 5)};
//   (62.3, 4.75) @TEXT("TOPN", size=0.6, halign="start");
//   &VCM @WIRE {#XDACN:VCM (44, 10)};
//   (44.25, 10.3) @TEXT("VCM", size=0.6, rotate=90, halign="start");
//   &VREFP @WIRE {#XDACN:VREFP (48, 10)};
//   (48.25, 10.3) @TEXT("VREFP", size=0.6, rotate=90, halign="start");
//   %g3 = $GROUND @ATTACH &0 => @PLACE(53.5, 9);
//   &0 @WIRE {#XDACN:VREFN (52, 9) (53.5, 9) %g3:p};
//   &PHI_S @WIRE {#XDACN:PHI_S (36, 2)};
//   (35.7, 1.75) @TEXT("PHI_S", size=0.6, halign="end");
//   &PHI_SB @WIRE {#XDACN:PHI_SB (36, 0)};
//   (35.7, -0.25) @TEXT("PHI_SB", size=0.6, halign="end");
//   &CONV @WIRE {#XDACN:CONV (36, -2)};
//   (35.7, -2.25) @TEXT("CONV", size=0.6, halign="end");
//   {&LO &LO &LO &LO &LO &LO &LO &LO &LO &LO &LO &LO &LO} @WIRE {#XDACN:DH12 (45, -10)};
//   (45.25, -10.3) @TEXT("LO,LO,LO,LO,LO,LO,LO,LO,LO,LO,LO,LO,LO", size=0.6, rotate=90, halign="end");
//   {&LO &LO &LO &LO &LO &LO &LO &LO &LO &LO &LO &LO &LO} @WIRE {#XDACN:RL12 (51, -10)};
//   (51.25, -10.3) @TEXT("LO,LO,LO,LO,LO,LO,LO,LO,LO,LO,LO,LO,LO", size=0.6, rotate=90, halign="end");
//   &VDDA @WIRE {#XDACN:DVDD (62, 0)};
//   (62.3, -0.25) @TEXT("VDDA", size=0.6, halign="start");
//   %g4 = $GROUND @ATTACH &0 => @PLACE(61.5, -4);
//   &0 @WIRE {#XDACN:VSS (61.5, -4) (61.5, -4) %g4:p};
//   &SRCP @WIRE {#VSP:1 (-16, 12)};
//   (-15.75, 12.3) @TEXT("SRCP", size=0.6, rotate=90, halign="start");
//   %g5 = $GROUND @ATTACH &0 => @PLACE(-16, 4.5);
//   &0 @WIRE {#VSP:2 %g5:p};
//   &SRCN @WIRE {#VSN:1 (-16, 3)};
//   (-15.75, 3.3) @TEXT("SRCN", size=0.6, rotate=90, halign="start");
//   %g6 = $GROUND @ATTACH &0 => @PLACE(-16, -4.5);
//   &0 @WIRE {#VSN:2 %g6:p};
//   &SRCP @WIRE {#RSP:1 (-16, -6)};
//   (-15.75, -5.7) @TEXT("SRCP", size=0.6, rotate=90, halign="start");
//   &VINP @WIRE {#RSP:2 (-16, -14)};
//   (-15.75, -14.3) @TEXT("VINP", size=0.6, rotate=90, halign="end");
//   &SRCN @WIRE {#RSN:1 (-16, -15)};
//   (-15.75, -14.7) @TEXT("SRCN", size=0.6, rotate=90, halign="start");
//   &VINN @WIRE {#RSN:2 (-16, -23)};
//   (-15.75, -23.3) @TEXT("VINN", size=0.6, rotate=90, halign="end");
//   &LO @WIRE {#VLO:1 (-16, -24)};
//   (-15.75, -23.7) @TEXT("LO", size=0.6, rotate=90, halign="start");
//   %g7 = $GROUND @ATTACH &0 => @PLACE(-16, -31.5);
//   &0 @WIRE {#VLO:2 %g7:p};
//   &TOPP @WIRE {#CTP:1 (0, -14)};
//   (0.25, -13.7) @TEXT("TOPP", size=0.6, rotate=90, halign="start");
//   %g8 = $GROUND @ATTACH &0 => @PLACE(0, -21.5);
//   &0 @WIRE {#CTP:2 %g8:p};
//   &TOPN @WIRE {#CTN:1 (8, -14)};
//   (8.25, -13.7) @TEXT("TOPN", size=0.6, rotate=90, halign="start");
//   %g9 = $GROUND @ATTACH &0 => @PLACE(8, -21.5);
//   &0 @WIRE {#CTN:2 %g9:p};
//   &VINP @WIRE {#IBSP:VIN (74, 5)};
//   (73.7, 4.75) @TEXT("VINP", size=0.6, halign="end");
//   &PHI_B @WIRE {#IBSP:PHI_B (74, 3)};
//   (73.7, 2.75) @TEXT("PHI_B", size=0.6, halign="end");
//   &PHI_BB @WIRE {#IBSP:PHI_BB (74, 1)};
//   (73.7, 0.75) @TEXT("PHI_BB", size=0.6, halign="end");
//   &VGP @WIRE {#IBSP:VG (90, 5)};
//   (90.3, 4.75) @TEXT("VGP", size=0.6, halign="start");
//   &VDDA @WIRE {#IBSP:AVDD (82, 10)};
//   (82.25, 10.3) @TEXT("VDDA", size=0.6, rotate=90, halign="start");
//   %g10 = $GROUND @ATTACH &0 => @PLACE(86, -3.5);
//   &0 @WIRE {#IBSP:VSS %g10:p};
//   &VINN @WIRE {#IBSN:VIN (74, -15)};
//   (73.7, -15.25) @TEXT("VINN", size=0.6, halign="end");
//   &PHI_B @WIRE {#IBSN:PHI_B (74, -17)};
//   (73.7, -17.25) @TEXT("PHI_B", size=0.6, halign="end");
//   &PHI_BB @WIRE {#IBSN:PHI_BB (74, -19)};
//   (73.7, -19.25) @TEXT("PHI_BB", size=0.6, halign="end");
//   &VGN @WIRE {#IBSN:VG (90, -15)};
//   (90.3, -15.25) @TEXT("VGN", size=0.6, halign="start");
//   &VDDA @WIRE {#IBSN:AVDD (82, -10)};
//   (82.25, -9.7) @TEXT("VDDA", size=0.6, rotate=90, halign="start");
//   %g11 = $GROUND @ATTACH &0 => @PLACE(86, -23.5);
//   &0 @WIRE {#IBSN:VSS %g11:p};
//   &TOPP @WIRE {#ISMP:P (74, -32)};
//   (73.7, -32.25) @TEXT("TOPP", size=0.6, halign="end");
//   &TOPN @WIRE {#ISMP:N (74, -34)};
//   (73.7, -34.25) @TEXT("TOPN", size=0.6, halign="end");
//   &CONV @WIRE {#ISMP:TRIG (80, -39)};
//   (80.25, -39.3) @TEXT("CONV", size=0.6, rotate=90, halign="end");
//   %g12 = $GROUND @ATTACH &0 => @PLACE(83, -38.5);
//   &0 @WIRE {#ISMP:VSS %g12:p};
//   &CLK @WIRE {#VCLK:1 (-16, -33)};
//   (-15.75, -32.7) @TEXT("CLK", size=0.6, rotate=90, halign="start");
//   %g13 = $GROUND @ATTACH &0 => @PLACE(-16, -40.5);
//   &0 @WIRE {#VCLK:2 %g13:p};
//   &CLK @WIRE {#ICG:CLK (74, -54)};
//   (73.7, -54.25) @TEXT("CLK", size=0.6, halign="end");
//   &PHI_S @WIRE {#ICG:PHI_S (90, -50)};
//   (90.3, -50.25) @TEXT("PHI_S", size=0.6, halign="start");
//   &PHI_SB @WIRE {#ICG:PHI_SB (90, -52)};
//   (90.3, -52.25) @TEXT("PHI_SB", size=0.6, halign="start");
//   &PHI_B @WIRE {#ICG:PHI_B (90, -54)};
//   (90.3, -54.25) @TEXT("PHI_B", size=0.6, halign="start");
//   &PHI_BB @WIRE {#ICG:PHI_BB (90, -56)};
//   (90.3, -56.25) @TEXT("PHI_BB", size=0.6, halign="start");
//   &CONV @WIRE {#ICG:CONV (90, -58)};
//   (90.3, -58.25) @TEXT("CONV", size=0.6, halign="start");
//   &VDDA @WIRE {#ICG:AVDD (82, -45)};
//   (82.25, -44.7) @TEXT("VDDA", size=0.6, rotate=90, halign="start");
//   %g14 = $GROUND @ATTACH &0 => @PLACE(82, -62.5);
//   &0 @WIRE {#ICG:VSS %g14:p};
//   &VDDA @WIRE {#VDDA:1 (0, 24)};
//   (0.25, 24.3) @TEXT("VDDA", size=0.6, rotate=90, halign="start");
//   %g15 = $GROUND @ATTACH &0 => @PLACE(0, 16.5);
//   &0 @WIRE {#VDDA:2 %g15:p};
//   &VREFP @WIRE {#VREFP:1 (12, 24)};
//   (12.25, 24.3) @TEXT("VREFP", size=0.6, rotate=90, halign="start");
//   %g16 = $GROUND @ATTACH &0 => @PLACE(12, 16.5);
//   &0 @WIRE {#VREFP:2 %g16:p};
//   &VCM @WIRE {#VVCM:1 (24, 24)};
//   (24.25, 24.3) @TEXT("VCM", size=0.6, rotate=90, halign="start");
//   %g17 = $GROUND @ATTACH &0 => @PLACE(24, 16.5);
//   &0 @WIRE {#VVCM:2 %g17:p};
//   (-30, 34) @TEXT("tb_cdac_track: sampling-network linearity of the two CDACs from 50 ohm", halign="start") => @SET-STYLE $title_style;
//   (-30, 32.4) @TEXT("V(TOPP) - V(TOPN) 300 ps after CONV rises (neutral DAC, no decisions) is the sampled input", halign="start") => @SET-STYLE $note_style
// }
