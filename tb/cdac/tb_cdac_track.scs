// tb_cdac_track: sampling-network linearity of the two CDACs from 50 ohm
// @RNL(type="header") {
//   @VERSION("0.3");
//   @USE-PACKAGE(name="adc28", version="0.1", path="../../design/rnl/adc28.rnl")
// }
// generated by `python -m adcflow gen` from specs/ -- do not edit (tools/adcflow/gen_tb.py)
// Globals vdd, vdd18, tempc, noise_en, devnoise, beh_speed, vref_in come from the run deck.
simulator lang=spectre
parameters fin=49.8046875e6 amp_dbfs=-1 npts=256 nskip=4 tper=10n fs_peak=0.9987 vcm_in=0.45 rsrc=50 ctop=15f
parameters amp=fs_peak*pow(10, amp_dbfs/20) tstart=nskip*tper tstop=(nskip+npts+0.5)*tper
XDACP (VINP VGP TOPP VCM VREFP 0 PHI_S PHI_SB CONV LO LO LO LO LO LO LO LO LO LO LO LO LO LO \
        LO LO LO LO LO LO LO LO LO LO LO LO VDDA 0) adc_cdac
XDACN (VINN VGN TOPN VCM VREFP 0 PHI_S PHI_SB CONV LO LO LO LO LO LO LO LO LO LO LO LO LO LO \
        LO LO LO LO LO LO LO LO LO LO LO LO VDDA 0) adc_cdac
VSP (SRCP 0) vsource type=sine sinedc=vcm_in ampl=amp/2 freq=fin
VSN (SRCN 0) vsource type=sine sinedc=vcm_in ampl=-amp/2 freq=fin
RSP (SRCP VINP) resistor r=rsrc
RSN (SRCN VINN) resistor r=rsrc
// all controls low: neutral DAC
VLO (LO 0) vsource dc=0
CTP (TOPP 0) capacitor c=ctop
CTN (TOPN 0) capacitor c=ctop
IBSP (VINP PHI_B PHI_BB VGP VDDA 0) adc_bootstrap_va kboost=1
IBSN (VINN PHI_B PHI_BB VGN VDDA 0) adc_bootstrap_va kboost=1
ISMP (TOPP TOPN CONV 0) tb_sampler_va dir=1 delay=0.3n tstart=tstart fname="samples.txt"
VCLK (CLK 0) vsource type=pulse val0=0 val1=vdd period=tper width=tper/2-20p rise=20p fall=20p
// ideal sampling phases
ICG (CLK PHI_S PHI_SB PHI_B PHI_BB CONV VDDA 0) adc_clkgen_va
VDDA (VDDA 0) vsource dc=vdd
VREFP (VREFP 0) vsource dc=vref_in
VVCM (VCM 0) vsource dc=vref_in/2
tran1 tran stop=tstop outputstart=tstop
tbopts options save=none reltol=1e-5 vabstol=1e-8
// @RNL {
//   /* --- semantics --- */
//   &0 @ADD-TO $GROUND_NET_SET;
//   #XDACP @PLACE(30, 0);
//   #XDACN @PLACE(106, 0);
//   #VSP @PLACE(-16, 7);
//   #VSN @PLACE(-16, -2);
//   #RSP @PLACE(-16, -11);
//   #RSN @PLACE(-16, -20);
//   #VLO @PLACE(-16, -29);
//   #VCLK @PLACE(-16, -38);
//   #IBSP @PLACE(159, 2);
//   #IBSN @PLACE(159, -18);
//   #ISMP @PLACE(159, -34);
//   #ICG @PLACE(159, -55);
//   #CTP @PLACE(0, -17);
//   #CTN @PLACE(8, -17);
//   #VDDA @PLACE(0, 19);
//   #VREFP @PLACE(12, 19);
//   #VVCM @PLACE(24, 19);
//   &VINP @WIRE {#XDACP:VIN (-2, 4)};
//   (-2.3, 3.75) @TEXT("VINP", size=0.6, halign="end");
//   &VGP @WIRE {#XDACP:VG (-2, 2)};
//   (-2.3, 1.75) @TEXT("VGP", size=0.6, halign="end");
//   &TOPP @WIRE {#XDACP:TOP (62, 0)};
//   (62.3, -0.25) @TEXT("TOPP", size=0.6, halign="start");
//   &VCM @WIRE {#XDACP:VCM (28, 9)};
//   (28.25, 9.3) @TEXT("VCM", size=0.6, rotate=90, halign="start");
//   &VREFP @WIRE {#XDACP:VREFP (30, 9)};
//   (30.25, 9.3) @TEXT("VREFP", size=0.6, rotate=90, halign="start");
//   %g1 = $GROUND @ATTACH &0 => @PLACE(3, -8.5);
//   &0 @WIRE {#XDACP:VREFN %g1:p};
//   &PHI_S @WIRE {#XDACP:PHI_S (-2, 0)};
//   (-2.3, -0.25) @TEXT("PHI_S", size=0.6, halign="end");
//   &PHI_SB @WIRE {#XDACP:PHI_SB (-2, -2)};
//   (-2.3, -2.25) @TEXT("PHI_SB", size=0.6, halign="end");
//   &CONV @WIRE {#XDACP:CONV (-2, -4)};
//   (-2.3, -4.25) @TEXT("CONV", size=0.6, halign="end");
//   &LO @WIRE {#XDACP:DH12 (5, -9)};
//   (5.25, -9.3) @TEXT("LO", size=0.6, rotate=90, halign="end");
//   &LO @WIRE {#XDACP:DH11 (7, -9)};
//   (7.25, -9.3) @TEXT("LO", size=0.6, rotate=90, halign="end");
//   &LO @WIRE {#XDACP:DH10 (9, -9)};
//   (9.25, -9.3) @TEXT("LO", size=0.6, rotate=90, halign="end");
//   &LO @WIRE {#XDACP:DH9 (11, -9)};
//   (11.25, -9.3) @TEXT("LO", size=0.6, rotate=90, halign="end");
//   &LO @WIRE {#XDACP:DH8 (13, -9)};
//   (13.25, -9.3) @TEXT("LO", size=0.6, rotate=90, halign="end");
//   &LO @WIRE {#XDACP:DH7 (15, -9)};
//   (15.25, -9.3) @TEXT("LO", size=0.6, rotate=90, halign="end");
//   &LO @WIRE {#XDACP:DH6 (17, -9)};
//   (17.25, -9.3) @TEXT("LO", size=0.6, rotate=90, halign="end");
//   &LO @WIRE {#XDACP:DH5 (19, -9)};
//   (19.25, -9.3) @TEXT("LO", size=0.6, rotate=90, halign="end");
//   &LO @WIRE {#XDACP:DH4 (21, -9)};
//   (21.25, -9.3) @TEXT("LO", size=0.6, rotate=90, halign="end");
//   &LO @WIRE {#XDACP:DH3 (23, -9)};
//   (23.25, -9.3) @TEXT("LO", size=0.6, rotate=90, halign="end");
//   &LO @WIRE {#XDACP:DH2 (25, -9)};
//   (25.25, -9.3) @TEXT("LO", size=0.6, rotate=90, halign="end");
//   &LO @WIRE {#XDACP:DH1 (27, -9)};
//   (27.25, -9.3) @TEXT("LO", size=0.6, rotate=90, halign="end");
//   &LO @WIRE {#XDACP:DH0 (29, -9)};
//   (29.25, -9.3) @TEXT("LO", size=0.6, rotate=90, halign="end");
//   &LO @WIRE {#XDACP:RL12 (31, -9)};
//   (31.25, -9.3) @TEXT("LO", size=0.6, rotate=90, halign="end");
//   &LO @WIRE {#XDACP:RL11 (33, -9)};
//   (33.25, -9.3) @TEXT("LO", size=0.6, rotate=90, halign="end");
//   &LO @WIRE {#XDACP:RL10 (35, -9)};
//   (35.25, -9.3) @TEXT("LO", size=0.6, rotate=90, halign="end");
//   &LO @WIRE {#XDACP:RL9 (37, -9)};
//   (37.25, -9.3) @TEXT("LO", size=0.6, rotate=90, halign="end");
//   &LO @WIRE {#XDACP:RL8 (39, -9)};
//   (39.25, -9.3) @TEXT("LO", size=0.6, rotate=90, halign="end");
//   &LO @WIRE {#XDACP:RL7 (41, -9)};
//   (41.25, -9.3) @TEXT("LO", size=0.6, rotate=90, halign="end");
//   &LO @WIRE {#XDACP:RL6 (43, -9)};
//   (43.25, -9.3) @TEXT("LO", size=0.6, rotate=90, halign="end");
//   &LO @WIRE {#XDACP:RL5 (45, -9)};
//   (45.25, -9.3) @TEXT("LO", size=0.6, rotate=90, halign="end");
//   &LO @WIRE {#XDACP:RL4 (47, -9)};
//   (47.25, -9.3) @TEXT("LO", size=0.6, rotate=90, halign="end");
//   &LO @WIRE {#XDACP:RL3 (49, -9)};
//   (49.25, -9.3) @TEXT("LO", size=0.6, rotate=90, halign="end");
//   &LO @WIRE {#XDACP:RL2 (51, -9)};
//   (51.25, -9.3) @TEXT("LO", size=0.6, rotate=90, halign="end");
//   &LO @WIRE {#XDACP:RL1 (53, -9)};
//   (53.25, -9.3) @TEXT("LO", size=0.6, rotate=90, halign="end");
//   &LO @WIRE {#XDACP:RL0 (55, -9)};
//   (55.25, -9.3) @TEXT("LO", size=0.6, rotate=90, halign="end");
//   &VDDA @WIRE {#XDACP:DVDD (32, 9)};
//   (32.25, 9.3) @TEXT("VDDA", size=0.6, rotate=90, halign="start");
//   %g2 = $GROUND @ATTACH &0 => @PLACE(57, -8.5);
//   &0 @WIRE {#XDACP:VSS %g2:p};
//   &VINN @WIRE {#XDACN:VIN (74, 4)};
//   (73.7, 3.75) @TEXT("VINN", size=0.6, halign="end");
//   &VGN @WIRE {#XDACN:VG (74, 2)};
//   (73.7, 1.75) @TEXT("VGN", size=0.6, halign="end");
//   &TOPN @WIRE {#XDACN:TOP (138, 0)};
//   (138.3, -0.25) @TEXT("TOPN", size=0.6, halign="start");
//   &VCM @WIRE {#XDACN:VCM (104, 9)};
//   (104.25, 9.3) @TEXT("VCM", size=0.6, rotate=90, halign="start");
//   &VREFP @WIRE {#XDACN:VREFP (106, 9)};
//   (106.25, 9.3) @TEXT("VREFP", size=0.6, rotate=90, halign="start");
//   %g3 = $GROUND @ATTACH &0 => @PLACE(79, -8.5);
//   &0 @WIRE {#XDACN:VREFN %g3:p};
//   &PHI_S @WIRE {#XDACN:PHI_S (74, 0)};
//   (73.7, -0.25) @TEXT("PHI_S", size=0.6, halign="end");
//   &PHI_SB @WIRE {#XDACN:PHI_SB (74, -2)};
//   (73.7, -2.25) @TEXT("PHI_SB", size=0.6, halign="end");
//   &CONV @WIRE {#XDACN:CONV (74, -4)};
//   (73.7, -4.25) @TEXT("CONV", size=0.6, halign="end");
//   &LO @WIRE {#XDACN:DH12 (81, -9)};
//   (81.25, -9.3) @TEXT("LO", size=0.6, rotate=90, halign="end");
//   &LO @WIRE {#XDACN:DH11 (83, -9)};
//   (83.25, -9.3) @TEXT("LO", size=0.6, rotate=90, halign="end");
//   &LO @WIRE {#XDACN:DH10 (85, -9)};
//   (85.25, -9.3) @TEXT("LO", size=0.6, rotate=90, halign="end");
//   &LO @WIRE {#XDACN:DH9 (87, -9)};
//   (87.25, -9.3) @TEXT("LO", size=0.6, rotate=90, halign="end");
//   &LO @WIRE {#XDACN:DH8 (89, -9)};
//   (89.25, -9.3) @TEXT("LO", size=0.6, rotate=90, halign="end");
//   &LO @WIRE {#XDACN:DH7 (91, -9)};
//   (91.25, -9.3) @TEXT("LO", size=0.6, rotate=90, halign="end");
//   &LO @WIRE {#XDACN:DH6 (93, -9)};
//   (93.25, -9.3) @TEXT("LO", size=0.6, rotate=90, halign="end");
//   &LO @WIRE {#XDACN:DH5 (95, -9)};
//   (95.25, -9.3) @TEXT("LO", size=0.6, rotate=90, halign="end");
//   &LO @WIRE {#XDACN:DH4 (97, -9)};
//   (97.25, -9.3) @TEXT("LO", size=0.6, rotate=90, halign="end");
//   &LO @WIRE {#XDACN:DH3 (99, -9)};
//   (99.25, -9.3) @TEXT("LO", size=0.6, rotate=90, halign="end");
//   &LO @WIRE {#XDACN:DH2 (101, -9)};
//   (101.25, -9.3) @TEXT("LO", size=0.6, rotate=90, halign="end");
//   &LO @WIRE {#XDACN:DH1 (103, -9)};
//   (103.25, -9.3) @TEXT("LO", size=0.6, rotate=90, halign="end");
//   &LO @WIRE {#XDACN:DH0 (105, -9)};
//   (105.25, -9.3) @TEXT("LO", size=0.6, rotate=90, halign="end");
//   &LO @WIRE {#XDACN:RL12 (107, -9)};
//   (107.25, -9.3) @TEXT("LO", size=0.6, rotate=90, halign="end");
//   &LO @WIRE {#XDACN:RL11 (109, -9)};
//   (109.25, -9.3) @TEXT("LO", size=0.6, rotate=90, halign="end");
//   &LO @WIRE {#XDACN:RL10 (111, -9)};
//   (111.25, -9.3) @TEXT("LO", size=0.6, rotate=90, halign="end");
//   &LO @WIRE {#XDACN:RL9 (113, -9)};
//   (113.25, -9.3) @TEXT("LO", size=0.6, rotate=90, halign="end");
//   &LO @WIRE {#XDACN:RL8 (115, -9)};
//   (115.25, -9.3) @TEXT("LO", size=0.6, rotate=90, halign="end");
//   &LO @WIRE {#XDACN:RL7 (117, -9)};
//   (117.25, -9.3) @TEXT("LO", size=0.6, rotate=90, halign="end");
//   &LO @WIRE {#XDACN:RL6 (119, -9)};
//   (119.25, -9.3) @TEXT("LO", size=0.6, rotate=90, halign="end");
//   &LO @WIRE {#XDACN:RL5 (121, -9)};
//   (121.25, -9.3) @TEXT("LO", size=0.6, rotate=90, halign="end");
//   &LO @WIRE {#XDACN:RL4 (123, -9)};
//   (123.25, -9.3) @TEXT("LO", size=0.6, rotate=90, halign="end");
//   &LO @WIRE {#XDACN:RL3 (125, -9)};
//   (125.25, -9.3) @TEXT("LO", size=0.6, rotate=90, halign="end");
//   &LO @WIRE {#XDACN:RL2 (127, -9)};
//   (127.25, -9.3) @TEXT("LO", size=0.6, rotate=90, halign="end");
//   &LO @WIRE {#XDACN:RL1 (129, -9)};
//   (129.25, -9.3) @TEXT("LO", size=0.6, rotate=90, halign="end");
//   &LO @WIRE {#XDACN:RL0 (131, -9)};
//   (131.25, -9.3) @TEXT("LO", size=0.6, rotate=90, halign="end");
//   &VDDA @WIRE {#XDACN:DVDD (108, 9)};
//   (108.25, 9.3) @TEXT("VDDA", size=0.6, rotate=90, halign="start");
//   %g4 = $GROUND @ATTACH &0 => @PLACE(133, -8.5);
//   &0 @WIRE {#XDACN:VSS %g4:p};
//   &SRCP @WIRE {#VSP:1 (-16, 11)};
//   (-15.75, 11.3) @TEXT("SRCP", size=0.6, rotate=90, halign="start");
//   %g5 = $GROUND @ATTACH &0 => @PLACE(-16, 3.5);
//   &0 @WIRE {#VSP:2 %g5:p};
//   &SRCN @WIRE {#VSN:1 (-16, 2)};
//   (-15.75, 2.3) @TEXT("SRCN", size=0.6, rotate=90, halign="start");
//   %g6 = $GROUND @ATTACH &0 => @PLACE(-16, -5.5);
//   &0 @WIRE {#VSN:2 %g6:p};
//   &SRCP @WIRE {#RSP:1 (-16, -7)};
//   (-15.75, -6.7) @TEXT("SRCP", size=0.6, rotate=90, halign="start");
//   &VINP @WIRE {#RSP:2 (-16, -15)};
//   (-15.75, -15.3) @TEXT("VINP", size=0.6, rotate=90, halign="end");
//   &SRCN @WIRE {#RSN:1 (-16, -16)};
//   (-15.75, -15.7) @TEXT("SRCN", size=0.6, rotate=90, halign="start");
//   &VINN @WIRE {#RSN:2 (-16, -24)};
//   (-15.75, -24.3) @TEXT("VINN", size=0.6, rotate=90, halign="end");
//   &LO @WIRE {#VLO:1 (-16, -25)};
//   (-15.75, -24.7) @TEXT("LO", size=0.6, rotate=90, halign="start");
//   %g7 = $GROUND @ATTACH &0 => @PLACE(-16, -32.5);
//   &0 @WIRE {#VLO:2 %g7:p};
//   &TOPP @WIRE {#CTP:1 (0, -13)};
//   (0.25, -12.7) @TEXT("TOPP", size=0.6, rotate=90, halign="start");
//   %g8 = $GROUND @ATTACH &0 => @PLACE(0, -20.5);
//   &0 @WIRE {#CTP:2 %g8:p};
//   &TOPN @WIRE {#CTN:1 (8, -13)};
//   (8.25, -12.7) @TEXT("TOPN", size=0.6, rotate=90, halign="start");
//   %g9 = $GROUND @ATTACH &0 => @PLACE(8, -20.5);
//   &0 @WIRE {#CTN:2 %g9:p};
//   &VINP @WIRE {#IBSP:VIN (150, 4)};
//   (149.7, 3.75) @TEXT("VINP", size=0.6, halign="end");
//   &PHI_B @WIRE {#IBSP:PHI_B (150, 2)};
//   (149.7, 1.75) @TEXT("PHI_B", size=0.6, halign="end");
//   &PHI_BB @WIRE {#IBSP:PHI_BB (150, 0)};
//   (149.7, -0.25) @TEXT("PHI_BB", size=0.6, halign="end");
//   &VGP @WIRE {#IBSP:VG (168, 2)};
//   (168.3, 1.75) @TEXT("VGP", size=0.6, halign="start");
//   &VDDA @WIRE {#IBSP:AVDD (159, 9)};
//   (159.25, 9.3) @TEXT("VDDA", size=0.6, rotate=90, halign="start");
//   %g10 = $GROUND @ATTACH &0 => @PLACE(159, -4.5);
//   &0 @WIRE {#IBSP:VSS %g10:p};
//   &VINN @WIRE {#IBSN:VIN (150, -16)};
//   (149.7, -16.25) @TEXT("VINN", size=0.6, halign="end");
//   &PHI_B @WIRE {#IBSN:PHI_B (150, -18)};
//   (149.7, -18.25) @TEXT("PHI_B", size=0.6, halign="end");
//   &PHI_BB @WIRE {#IBSN:PHI_BB (150, -20)};
//   (149.7, -20.25) @TEXT("PHI_BB", size=0.6, halign="end");
//   &VGN @WIRE {#IBSN:VG (168, -18)};
//   (168.3, -18.25) @TEXT("VGN", size=0.6, halign="start");
//   &VDDA @WIRE {#IBSN:AVDD (159, -11)};
//   (159.25, -10.7) @TEXT("VDDA", size=0.6, rotate=90, halign="start");
//   %g11 = $GROUND @ATTACH &0 => @PLACE(159, -24.5);
//   &0 @WIRE {#IBSN:VSS %g11:p};
//   &TOPP @WIRE {#ISMP:P (150, -33)};
//   (149.7, -33.25) @TEXT("TOPP", size=0.6, halign="end");
//   &TOPN @WIRE {#ISMP:N (150, -35)};
//   (149.7, -35.25) @TEXT("TOPN", size=0.6, halign="end");
//   &CONV @WIRE {#ISMP:TRIG (157, -40)};
//   (157.25, -40.3) @TEXT("CONV", size=0.6, rotate=90, halign="end");
//   %g12 = $GROUND @ATTACH &0 => @PLACE(161, -39.5);
//   &0 @WIRE {#ISMP:VSS %g12:p};
//   &CLK @WIRE {#VCLK:1 (-16, -34)};
//   (-15.75, -33.7) @TEXT("CLK", size=0.6, rotate=90, halign="start");
//   %g13 = $GROUND @ATTACH &0 => @PLACE(-16, -41.5);
//   &0 @WIRE {#VCLK:2 %g13:p};
//   &CLK @WIRE {#ICG:CLK (150, -55)};
//   (149.7, -55.25) @TEXT("CLK", size=0.6, halign="end");
//   &PHI_S @WIRE {#ICG:PHI_S (168, -51)};
//   (168.3, -51.25) @TEXT("PHI_S", size=0.6, halign="start");
//   &PHI_SB @WIRE {#ICG:PHI_SB (168, -53)};
//   (168.3, -53.25) @TEXT("PHI_SB", size=0.6, halign="start");
//   &PHI_B @WIRE {#ICG:PHI_B (168, -55)};
//   (168.3, -55.25) @TEXT("PHI_B", size=0.6, halign="start");
//   &PHI_BB @WIRE {#ICG:PHI_BB (168, -57)};
//   (168.3, -57.25) @TEXT("PHI_BB", size=0.6, halign="start");
//   &CONV @WIRE {#ICG:CONV (168, -59)};
//   (168.3, -59.25) @TEXT("CONV", size=0.6, halign="start");
//   &VDDA @WIRE {#ICG:AVDD (159, -46)};
//   (159.25, -45.7) @TEXT("VDDA", size=0.6, rotate=90, halign="start");
//   %g14 = $GROUND @ATTACH &0 => @PLACE(159, -63.5);
//   &0 @WIRE {#ICG:VSS %g14:p};
//   &VDDA @WIRE {#VDDA:1 (0, 23)};
//   (0.25, 23.3) @TEXT("VDDA", size=0.6, rotate=90, halign="start");
//   %g15 = $GROUND @ATTACH &0 => @PLACE(0, 15.5);
//   &0 @WIRE {#VDDA:2 %g15:p};
//   &VREFP @WIRE {#VREFP:1 (12, 23)};
//   (12.25, 23.3) @TEXT("VREFP", size=0.6, rotate=90, halign="start");
//   %g16 = $GROUND @ATTACH &0 => @PLACE(12, 15.5);
//   &0 @WIRE {#VREFP:2 %g16:p};
//   &VCM @WIRE {#VVCM:1 (24, 23)};
//   (24.25, 23.3) @TEXT("VCM", size=0.6, rotate=90, halign="start");
//   %g17 = $GROUND @ATTACH &0 => @PLACE(24, 15.5);
//   &0 @WIRE {#VVCM:2 %g17:p};
//   (-30, 33) @TEXT("tb_cdac_track: sampling-network linearity of the two CDACs from 50 ohm", halign="start") => @SET-STYLE $title_style;
//   (-30, 31.4) @TEXT("V(TOPP) - V(TOPN) 300 ps after CONV rises (neutral DAC, no decisions) is the sampled input", halign="start") => @SET-STYLE $note_style
// }
