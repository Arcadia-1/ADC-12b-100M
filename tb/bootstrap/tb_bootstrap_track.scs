// tb_bootstrap_track: differential tracking linearity with the reference switch
// @RNL(type="header") {
//   @VERSION("0.3");
//   @USE-PACKAGE(name="adc28", version="0.1", path="../../design/rnl/adc28.rnl")
// }
// generated by `python -m adcflow gen` from specs/ -- do not edit (tools/adcflow/gen_tb.py)
// Globals vdd, vdd18, tempc, noise_en, devnoise, beh_speed, vref_in come from the run deck.
simulator lang=spectre
parameters fin=49.8046875e6 amp_dbfs=-1 npts=256 nskip=4 tper=10n fs_peak=0.9987 vcm_in=0.45 rsrc=50 wsw=48u cs=1.0235p
parameters amp=fs_peak*pow(10, amp_dbfs/20) tstart=nskip*tper tstop=(nskip+npts+0.5)*tper
XBSP (VINP PHI_B PHI_BB VGP AVDD 0) adc_bootstrap
XBSN (VINN PHI_B PHI_BB VGN AVDD 0) adc_bootstrap
VSP (SRCP 0) vsource type=sine sinedc=vcm_in ampl=amp/2 freq=fin
VSN (SRCN 0) vsource type=sine sinedc=vcm_in ampl=-amp/2 freq=fin
RSP (SRCP VINP) resistor r=rsrc
RSN (SRCN VINN) resistor r=rsrc
// bottom-plate voltages at the PHI_S falling edges
ISMP (BPP BPN PHI_S 0) tb_sampler_va dir=-1 delay=0 tstart=tstart fname="samples.txt"
// reference input switch of one CDAC side
MSWP (BPP VGP VINP 0) nch_ulvt_mac w=wsw l=30n nf=24
CSP (BPP TOPRP) capacitor c=cs
STOPP (TOPRP VCM PHI_S 0) relay vt1=0.35 vt2=0.55 ropen=1e12 rclosed=20
CVGP (VGP 0) capacitor c=10f
// reference input switch of one CDAC side
MSWN (BPN VGN VINN 0) nch_ulvt_mac w=wsw l=30n nf=24
CSN (BPN TOPRN) capacitor c=cs
STOPN (TOPRN VCM PHI_S 0) relay vt1=0.35 vt2=0.55 ropen=1e12 rclosed=20
CVGN (VGN 0) capacitor c=10f
VCLK (CLK 0) vsource type=pulse val0=0 val1=vdd period=tper width=tper/2-20p rise=20p fall=20p
// ideal sampling phases
ICG (CLK PHI_S PHI_SB PHI_B PHI_BB CONV VDDA 0) adc_clkgen_va
VDDA (VDDA 0) vsource dc=vdd
VVCM (VCM 0) vsource dc=vref_in/2
VAVDD (AVDD 0) vsource dc=vdd
tran1 tran stop=tstop outputstart=tstop
tbopts options save=none reltol=1e-5 vabstol=1e-8
// @RNL {
//   /* --- semantics --- */
//   &0 @ADD-TO $GROUND_NET_SET;
//   #XBSP @PLACE(7, 0);
//   #XBSN @PLACE(37, 0);
//   #VSP @PLACE(-16, 5);
//   #VSN @PLACE(-16, -4);
//   #RSP @PLACE(-16, -13);
//   #RSN @PLACE(-16, -22);
//   #VCLK @PLACE(-16, -31);
//   #ISMP @PLACE(67, 4);
//   #ICG @PLACE(67, -17);
//   #MSWP @PLACE(0, -15);
//   #CSP @PLACE(8, -15);
//   #STOPP @PLACE(16, -15);
//   #CVGP @PLACE(24, -15);
//   #MSWN @PLACE(32, -15);
//   #CSN @PLACE(40, -15);
//   #STOPN @PLACE(48, -15);
//   #CVGN @PLACE(56, -15);
//   #VDDA @PLACE(0, 17);
//   #VVCM @PLACE(12, 17);
//   #VAVDD @PLACE(24, 17);
//   &VINP @WIRE {#XBSP:VIN (-2, 2)};
//   (-2.3, 1.75) @TEXT("VINP", size=0.6, halign="end");
//   &PHI_B @WIRE {#XBSP:PHI_B (-2, 0)};
//   (-2.3, -0.25) @TEXT("PHI_B", size=0.6, halign="end");
//   &PHI_BB @WIRE {#XBSP:PHI_BB (-2, -2)};
//   (-2.3, -2.25) @TEXT("PHI_BB", size=0.6, halign="end");
//   &VGP @WIRE {#XBSP:VG (16, 0)};
//   (16.3, -0.25) @TEXT("VGP", size=0.6, halign="start");
//   &AVDD @WIRE {#XBSP:AVDD (7, 7)};
//   (7.25, 7.3) @TEXT("AVDD", size=0.6, rotate=90, halign="start");
//   %g1 = $GROUND @ATTACH &0 => @PLACE(7, -6.5);
//   &0 @WIRE {#XBSP:VSS %g1:p};
//   &VINN @WIRE {#XBSN:VIN (28, 2)};
//   (27.7, 1.75) @TEXT("VINN", size=0.6, halign="end");
//   &PHI_B @WIRE {#XBSN:PHI_B (28, 0)};
//   (27.7, -0.25) @TEXT("PHI_B", size=0.6, halign="end");
//   &PHI_BB @WIRE {#XBSN:PHI_BB (28, -2)};
//   (27.7, -2.25) @TEXT("PHI_BB", size=0.6, halign="end");
//   &VGN @WIRE {#XBSN:VG (46, 0)};
//   (46.3, -0.25) @TEXT("VGN", size=0.6, halign="start");
//   &AVDD @WIRE {#XBSN:AVDD (37, 7)};
//   (37.25, 7.3) @TEXT("AVDD", size=0.6, rotate=90, halign="start");
//   %g2 = $GROUND @ATTACH &0 => @PLACE(37, -6.5);
//   &0 @WIRE {#XBSN:VSS %g2:p};
//   &SRCP @WIRE {#VSP:1 (-16, 9)};
//   (-15.75, 9.3) @TEXT("SRCP", size=0.6, rotate=90, halign="start");
//   %g3 = $GROUND @ATTACH &0 => @PLACE(-16, 1.5);
//   &0 @WIRE {#VSP:2 %g3:p};
//   &SRCN @WIRE {#VSN:1 (-16, 0)};
//   (-15.75, 0.3) @TEXT("SRCN", size=0.6, rotate=90, halign="start");
//   %g4 = $GROUND @ATTACH &0 => @PLACE(-16, -7.5);
//   &0 @WIRE {#VSN:2 %g4:p};
//   &SRCP @WIRE {#RSP:1 (-16, -9)};
//   (-15.75, -8.7) @TEXT("SRCP", size=0.6, rotate=90, halign="start");
//   &VINP @WIRE {#RSP:2 (-16, -17)};
//   (-15.75, -17.3) @TEXT("VINP", size=0.6, rotate=90, halign="end");
//   &SRCN @WIRE {#RSN:1 (-16, -18)};
//   (-15.75, -17.7) @TEXT("SRCN", size=0.6, rotate=90, halign="start");
//   &VINN @WIRE {#RSN:2 (-16, -26)};
//   (-15.75, -26.3) @TEXT("VINN", size=0.6, rotate=90, halign="end");
//   &BPP @WIRE {#ISMP:P (58, 5)};
//   (57.7, 4.75) @TEXT("BPP", size=0.6, halign="end");
//   &BPN @WIRE {#ISMP:N (58, 3)};
//   (57.7, 2.75) @TEXT("BPN", size=0.6, halign="end");
//   &PHI_S @WIRE {#ISMP:TRIG (65, -2)};
//   (65.25, -2.3) @TEXT("PHI_S", size=0.6, rotate=90, halign="end");
//   %g5 = $GROUND @ATTACH &0 => @PLACE(69, -1.5);
//   &0 @WIRE {#ISMP:VSS %g5:p};
//   &BPP @WIRE {#MSWP:1 (0, -11)};
//   (0.25, -10.7) @TEXT("BPP", size=0.6, rotate=90, halign="start");
//   &VGP @WIRE {#MSWP:2 (-5, -15)};
//   (-5.3, -15.25) @TEXT("VGP", size=0.6, halign="end");
//   &VINP @WIRE {#MSWP:3 (0, -19)};
//   (0.25, -19.3) @TEXT("VINP", size=0.6, rotate=90, halign="end");
//   %g6 = $GROUND @ATTACH &0 => @PLACE(2.5, -15);
//   &0 @WIRE {#MSWP:4 (2.5, -15) (2.5, -15) %g6:p};
//   &BPP @WIRE {#CSP:1 (8, -11)};
//   (8.25, -10.7) @TEXT("BPP", size=0.6, rotate=90, halign="start");
//   &TOPRP @WIRE {#CSP:2 (8, -19)};
//   (8.25, -19.3) @TEXT("TOPRP", size=0.6, rotate=90, halign="end");
//   &TOPRP @WIRE {#STOPP:1 (12, -15)};
//   (11.7, -15.25) @TEXT("TOPRP", size=0.6, halign="end");
//   &VCM @WIRE {#STOPP:2 (20, -15)};
//   (20.3, -15.25) @TEXT("VCM", size=0.6, halign="start");
//   &PHI_S @WIRE {#STOPP:3 (12, -18)};
//   (11.7, -18.25) @TEXT("PHI_S", size=0.6, halign="end");
//   %g7 = $GROUND @ATTACH &0 => @PLACE(19.5, -18);
//   &0 @WIRE {#STOPP:4 (19.5, -18) (19.5, -18) %g7:p};
//   &VGP @WIRE {#CVGP:1 (24, -11)};
//   (24.25, -10.7) @TEXT("VGP", size=0.6, rotate=90, halign="start");
//   %g8 = $GROUND @ATTACH &0 => @PLACE(24, -18.5);
//   &0 @WIRE {#CVGP:2 %g8:p};
//   &BPN @WIRE {#MSWN:1 (32, -11)};
//   (32.25, -10.7) @TEXT("BPN", size=0.6, rotate=90, halign="start");
//   &VGN @WIRE {#MSWN:2 (27, -15)};
//   (26.7, -15.25) @TEXT("VGN", size=0.6, halign="end");
//   &VINN @WIRE {#MSWN:3 (32, -19)};
//   (32.25, -19.3) @TEXT("VINN", size=0.6, rotate=90, halign="end");
//   %g9 = $GROUND @ATTACH &0 => @PLACE(34.5, -15);
//   &0 @WIRE {#MSWN:4 (34.5, -15) (34.5, -15) %g9:p};
//   &BPN @WIRE {#CSN:1 (40, -11)};
//   (40.25, -10.7) @TEXT("BPN", size=0.6, rotate=90, halign="start");
//   &TOPRN @WIRE {#CSN:2 (40, -19)};
//   (40.25, -19.3) @TEXT("TOPRN", size=0.6, rotate=90, halign="end");
//   &TOPRN @WIRE {#STOPN:1 (44, -15)};
//   (43.7, -15.25) @TEXT("TOPRN", size=0.6, halign="end");
//   &VCM @WIRE {#STOPN:2 (52, -15)};
//   (52.3, -15.25) @TEXT("VCM", size=0.6, halign="start");
//   &PHI_S @WIRE {#STOPN:3 (44, -18)};
//   (43.7, -18.25) @TEXT("PHI_S", size=0.6, halign="end");
//   %g10 = $GROUND @ATTACH &0 => @PLACE(51.5, -18);
//   &0 @WIRE {#STOPN:4 (51.5, -18) (51.5, -18) %g10:p};
//   &VGN @WIRE {#CVGN:1 (56, -11)};
//   (56.25, -10.7) @TEXT("VGN", size=0.6, rotate=90, halign="start");
//   %g11 = $GROUND @ATTACH &0 => @PLACE(56, -18.5);
//   &0 @WIRE {#CVGN:2 %g11:p};
//   &CLK @WIRE {#VCLK:1 (-16, -27)};
//   (-15.75, -26.7) @TEXT("CLK", size=0.6, rotate=90, halign="start");
//   %g12 = $GROUND @ATTACH &0 => @PLACE(-16, -34.5);
//   &0 @WIRE {#VCLK:2 %g12:p};
//   &CLK @WIRE {#ICG:CLK (58, -17)};
//   (57.7, -17.25) @TEXT("CLK", size=0.6, halign="end");
//   &PHI_S @WIRE {#ICG:PHI_S (76, -13)};
//   (76.3, -13.25) @TEXT("PHI_S", size=0.6, halign="start");
//   &PHI_SB @WIRE {#ICG:PHI_SB (76, -15)};
//   (76.3, -15.25) @TEXT("PHI_SB", size=0.6, halign="start");
//   &PHI_B @WIRE {#ICG:PHI_B (76, -17)};
//   (76.3, -17.25) @TEXT("PHI_B", size=0.6, halign="start");
//   &PHI_BB @WIRE {#ICG:PHI_BB (76, -19)};
//   (76.3, -19.25) @TEXT("PHI_BB", size=0.6, halign="start");
//   &CONV @WIRE {#ICG:CONV (76, -21)};
//   (76.3, -21.25) @TEXT("CONV", size=0.6, halign="start");
//   &VDDA @WIRE {#ICG:AVDD (67, -8)};
//   (67.25, -7.7) @TEXT("VDDA", size=0.6, rotate=90, halign="start");
//   %g13 = $GROUND @ATTACH &0 => @PLACE(67, -25.5);
//   &0 @WIRE {#ICG:VSS %g13:p};
//   &VDDA @WIRE {#VDDA:1 (0, 21)};
//   (0.25, 21.3) @TEXT("VDDA", size=0.6, rotate=90, halign="start");
//   %g14 = $GROUND @ATTACH &0 => @PLACE(0, 13.5);
//   &0 @WIRE {#VDDA:2 %g14:p};
//   &VCM @WIRE {#VVCM:1 (12, 21)};
//   (12.25, 21.3) @TEXT("VCM", size=0.6, rotate=90, halign="start");
//   %g15 = $GROUND @ATTACH &0 => @PLACE(12, 13.5);
//   &0 @WIRE {#VVCM:2 %g15:p};
//   &AVDD @WIRE {#VAVDD:1 (24, 21)};
//   (24.25, 21.3) @TEXT("AVDD", size=0.6, rotate=90, halign="start");
//   %g16 = $GROUND @ATTACH &0 => @PLACE(24, 13.5);
//   &0 @WIRE {#VAVDD:2 %g16:p};
//   (-30, 31) @TEXT("tb_bootstrap_track: differential tracking linearity with the reference switch", halign="start") => @SET-STYLE $title_style
// }
