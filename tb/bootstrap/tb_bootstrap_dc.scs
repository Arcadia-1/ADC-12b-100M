// tb_bootstrap_dc: boosted gate over the input range, edges, current
// @RNL(type="header") {
//   @VERSION("0.3");
//   @USE-PACKAGE(name="adc28", version="0.1", path="../../design/rnl/adc28.rnl")
// }
// generated by `python -m adcflow gen` from specs/ -- do not edit (tools/adcflow/gen_tb.py)
// Globals vdd, vdd18, tempc, noise_en, devnoise, beh_speed, vref_in come from the run deck.
simulator lang=spectre
parameters tper=10n rsrc=50 wsw=48u cs=1.0235p
parameters tstop=29*tper
XDUT (VIN PHI_B PHI_BB VG AVDD 0) adc_bootstrap
VSRC (SRC 0) vsource type=pwl wave=[0.0000e+00 0 4.0300e-08 0 4.0500e-08 0.15 8.0300e-08 0.15 8.0500e-08 0.3 1.2030e-07 0.3 1.2050e-07 0.45 1.6030e-07 0.45 1.6050e-07 0.6 2.0030e-07 0.6 2.0050e-07 0.75 2.4030e-07 0.75 2.4050e-07 0.9]
RS (SRC VIN) resistor r=rsrc
// VG - VIN at the sampling instants
ISMP (VG VIN PHI_S 0) tb_sampler_va dir=-1 delay=0 fname="vgs.txt"
// reference input switch of one CDAC side
MSWP (BP VG VIN 0) nch_ulvt_mac w=wsw l=30n nf=24
CSP (BP TOPR) capacitor c=cs
STOPP (TOPR VCM PHI_S 0) relay vt1=0.35 vt2=0.55 ropen=1e12 rclosed=20
CVGP (VG 0) capacitor c=10f
VCLK (CLK 0) vsource type=pulse val0=0 val1=vdd period=tper width=tper/2-20p rise=20p fall=20p
// ideal sampling phases
ICG (CLK PHI_S PHI_SB PHI_B PHI_BB CONV VDDA 0) adc_clkgen_va
VDDA (VDDA 0) vsource dc=vdd
VVCM (VCM 0) vsource dc=vref_in/2
VAVDD (AVDD_S 0) vsource dc=vdd
IMAVDD (AVDD_S AVDD) tb_imeter_va tstart=tper tstop=tstop label="AVDD" fname="power.txt"
tran1 tran stop=tstop
save VG VIN PHI_B BP
// @RNL {
//   /* --- semantics --- */
//   &0 @ADD-TO $GROUND_NET_SET;
//   #XDUT @PLACE(7, 0);
//   #VSRC @PLACE(-16, 5);
//   #RS @PLACE(-16, -4);
//   #VCLK @PLACE(-16, -13);
//   #ISMP @PLACE(37, 4);
//   #ICG @PLACE(37, -17);
//   #MSWP @PLACE(0, -15);
//   #CSP @PLACE(8, -15);
//   #STOPP @PLACE(16, -15);
//   #CVGP @PLACE(24, -15);
//   #VDDA @PLACE(0, 17);
//   #VVCM @PLACE(12, 17);
//   #VAVDD @PLACE(24, 17);
//   #IMAVDD @PLACE(36, 19);
//   &VIN @WIRE {#XDUT:VIN (-2, 2)};
//   (-2.3, 1.75) @TEXT("VIN", size=0.6, halign="end");
//   &PHI_B @WIRE {#XDUT:PHI_B (-2, 0)};
//   (-2.3, -0.25) @TEXT("PHI_B", size=0.6, halign="end");
//   &PHI_BB @WIRE {#XDUT:PHI_BB (-2, -2)};
//   (-2.3, -2.25) @TEXT("PHI_BB", size=0.6, halign="end");
//   &VG @WIRE {#XDUT:VG (16, 0)};
//   (16.3, -0.25) @TEXT("VG", size=0.6, halign="start");
//   &AVDD @WIRE {#XDUT:AVDD (7, 7)};
//   (7.25, 7.3) @TEXT("AVDD", size=0.6, rotate=90, halign="start");
//   %g1 = $GROUND @ATTACH &0 => @PLACE(7, -6.5);
//   &0 @WIRE {#XDUT:VSS %g1:p};
//   &SRC @WIRE {#VSRC:1 (-16, 9)};
//   (-15.75, 9.3) @TEXT("SRC", size=0.6, rotate=90, halign="start");
//   %g2 = $GROUND @ATTACH &0 => @PLACE(-16, 1.5);
//   &0 @WIRE {#VSRC:2 %g2:p};
//   &SRC @WIRE {#RS:1 (-16, 0)};
//   (-15.75, 0.3) @TEXT("SRC", size=0.6, rotate=90, halign="start");
//   &VIN @WIRE {#RS:2 (-16, -8)};
//   (-15.75, -8.3) @TEXT("VIN", size=0.6, rotate=90, halign="end");
//   &VG @WIRE {#ISMP:P (28, 5)};
//   (27.7, 4.75) @TEXT("VG", size=0.6, halign="end");
//   &VIN @WIRE {#ISMP:N (28, 3)};
//   (27.7, 2.75) @TEXT("VIN", size=0.6, halign="end");
//   &PHI_S @WIRE {#ISMP:TRIG (35, -2)};
//   (35.25, -2.3) @TEXT("PHI_S", size=0.6, rotate=90, halign="end");
//   %g3 = $GROUND @ATTACH &0 => @PLACE(39, -1.5);
//   &0 @WIRE {#ISMP:VSS %g3:p};
//   &BP @WIRE {#MSWP:1 (0, -11)};
//   (0.25, -10.7) @TEXT("BP", size=0.6, rotate=90, halign="start");
//   &VG @WIRE {#MSWP:2 (-5, -15)};
//   (-5.3, -15.25) @TEXT("VG", size=0.6, halign="end");
//   &VIN @WIRE {#MSWP:3 (0, -19)};
//   (0.25, -19.3) @TEXT("VIN", size=0.6, rotate=90, halign="end");
//   %g4 = $GROUND @ATTACH &0 => @PLACE(2.5, -15);
//   &0 @WIRE {#MSWP:4 (2.5, -15) (2.5, -15) %g4:p};
//   &BP @WIRE {#CSP:1 (8, -11)};
//   (8.25, -10.7) @TEXT("BP", size=0.6, rotate=90, halign="start");
//   &TOPR @WIRE {#CSP:2 (8, -19)};
//   (8.25, -19.3) @TEXT("TOPR", size=0.6, rotate=90, halign="end");
//   &TOPR @WIRE {#STOPP:1 (12, -15)};
//   (11.7, -15.25) @TEXT("TOPR", size=0.6, halign="end");
//   &VCM @WIRE {#STOPP:2 (20, -15)};
//   (20.3, -15.25) @TEXT("VCM", size=0.6, halign="start");
//   &PHI_S @WIRE {#STOPP:3 (12, -18)};
//   (11.7, -18.25) @TEXT("PHI_S", size=0.6, halign="end");
//   %g5 = $GROUND @ATTACH &0 => @PLACE(19.5, -18);
//   &0 @WIRE {#STOPP:4 (19.5, -18) (19.5, -18) %g5:p};
//   &VG @WIRE {#CVGP:1 (24, -11)};
//   (24.25, -10.7) @TEXT("VG", size=0.6, rotate=90, halign="start");
//   %g6 = $GROUND @ATTACH &0 => @PLACE(24, -18.5);
//   &0 @WIRE {#CVGP:2 %g6:p};
//   &CLK @WIRE {#VCLK:1 (-16, -9)};
//   (-15.75, -8.7) @TEXT("CLK", size=0.6, rotate=90, halign="start");
//   %g7 = $GROUND @ATTACH &0 => @PLACE(-16, -16.5);
//   &0 @WIRE {#VCLK:2 %g7:p};
//   &CLK @WIRE {#ICG:CLK (28, -17)};
//   (27.7, -17.25) @TEXT("CLK", size=0.6, halign="end");
//   &PHI_S @WIRE {#ICG:PHI_S (46, -13)};
//   (46.3, -13.25) @TEXT("PHI_S", size=0.6, halign="start");
//   &PHI_SB @WIRE {#ICG:PHI_SB (46, -15)};
//   (46.3, -15.25) @TEXT("PHI_SB", size=0.6, halign="start");
//   &PHI_B @WIRE {#ICG:PHI_B (46, -17)};
//   (46.3, -17.25) @TEXT("PHI_B", size=0.6, halign="start");
//   &PHI_BB @WIRE {#ICG:PHI_BB (46, -19)};
//   (46.3, -19.25) @TEXT("PHI_BB", size=0.6, halign="start");
//   &CONV @WIRE {#ICG:CONV (46, -21)};
//   (46.3, -21.25) @TEXT("CONV", size=0.6, halign="start");
//   &VDDA @WIRE {#ICG:AVDD (37, -8)};
//   (37.25, -7.7) @TEXT("VDDA", size=0.6, rotate=90, halign="start");
//   %g8 = $GROUND @ATTACH &0 => @PLACE(37, -25.5);
//   &0 @WIRE {#ICG:VSS %g8:p};
//   &VDDA @WIRE {#VDDA:1 (0, 21)};
//   (0.25, 21.3) @TEXT("VDDA", size=0.6, rotate=90, halign="start");
//   %g9 = $GROUND @ATTACH &0 => @PLACE(0, 13.5);
//   &0 @WIRE {#VDDA:2 %g9:p};
//   &VCM @WIRE {#VVCM:1 (12, 21)};
//   (12.25, 21.3) @TEXT("VCM", size=0.6, rotate=90, halign="start");
//   %g10 = $GROUND @ATTACH &0 => @PLACE(12, 13.5);
//   &0 @WIRE {#VVCM:2 %g10:p};
//   &AVDD_S @WIRE {#VAVDD:1 (24, 21)};
//   (24.25, 21.3) @TEXT("AVDD_S", size=0.6, rotate=90, halign="start");
//   %g11 = $GROUND @ATTACH &0 => @PLACE(24, 13.5);
//   &0 @WIRE {#VAVDD:2 %g11:p};
//   &AVDD_S @WIRE {#IMAVDD:P (36, 25)};
//   (36.25, 25.3) @TEXT("AVDD_S", size=0.6, rotate=90, halign="start");
//   &AVDD @WIRE {#IMAVDD:N (36, 13)};
//   (36.25, 12.7) @TEXT("AVDD", size=0.6, rotate=90, halign="end");
//   (-30, 31) @TEXT("tb_bootstrap_dc: boosted gate over the input range, edges, current", halign="start") => @SET-STYLE $title_style;
//   (-30, 29.4) @TEXT("VIN steps 0 .. 0.9 V in 0.15 V steps, 4 cycles each, through 50 ohm with the reference switch load", halign="start") => @SET-STYLE $note_style
// }
