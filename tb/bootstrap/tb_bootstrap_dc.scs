// tb_bootstrap_dc: boosted gate over the input range, edges, current
// @RNL(type="header") {
//   @VERSION("0.3");
//   @USE-PACKAGE(name="adc28", version="0.1", path="../../design/rnl/adc28.rnl")
// }
// generated by `python -m adcflow gen` from specs/ -- do not edit (tools/adcflow/gen_tb.py)
// Globals vdd, vdd18, tempc, noise_en, devnoise, beh_speed, vref_in come from the run deck.
simulator lang=spectre
parameters tper=10n rsrc=50 wsw=48u cs=1.0235p
parameters tstop=29*tper
XDUT (VIN PHI_B PHI_BB VG AVDD 0) adc_bootstrap
VSRC (SRC 0) vsource type=pwl wave=[0.0000e+00 0 4.0300e-08 0 4.0500e-08 0.15 8.0300e-08 0.15 8.0500e-08 0.3 1.2030e-07 0.3 1.2050e-07 0.45 1.6030e-07 0.45 1.6050e-07 0.6 2.0030e-07 0.6 2.0050e-07 0.75 2.4030e-07 0.75 2.4050e-07 0.9]
RS (SRC VIN) resistor r=rsrc
// VG - VIN at the sampling instants
ISMP (VG VIN PHI_S 0) tb_sampler_va dir=-1 delay=0 fname="vgs.txt"
// reference input switch of one CDAC side
MSWP (BP VG VIN 0) nch_ulvt_mac w=wsw l=30n nf=24
CSP (BP TOPR) capacitor c=cs
STOPP (TOPR VCM PHI_S 0) relay vt1=0.35 vt2=0.55 ropen=1e12 rclosed=20
CVGP (VG 0) capacitor c=10f
VCLK (CLK 0) vsource type=pulse val0=0 val1=vdd period=tper width=tper/2-20p rise=20p fall=20p
// ideal sampling phases
ICG (CLK PHI_S PHI_SB PHI_B PHI_BB CONV VDDA 0) adc_clkgen_va
VDDA (VDDA 0) vsource dc=vdd
VVCM (VCM 0) vsource dc=vref_in/2
VAVDD (AVDD_S 0) vsource dc=vdd
IMAVDD (AVDD_S AVDD) tb_imeter_va tstart=tper tstop=tstop label="AVDD" fname="power.txt"
tran1 tran stop=tstop
save VG VIN PHI_B BP
// @RNL {
//   /* pins connected by net name: the net-name label of rnl-std-fill on every unwired pin, placed below by its key netname */
//   $LABEL_TERMINAL_SET @TEXT("${net}", key="netname", size=0.6);
//   /* --- semantics --- */
//   &0 @ADD-TO $GROUND_NET_SET;
//   #XDUT @PLACE(6, 0);
//   #VSRC @PLACE(-16, 5);
//   #RS @PLACE(-16, -4);
//   #VCLK @PLACE(-16, -13);
//   #ISMP @PLACE(33, 4);
//   #ICG @PLACE(34, -17);
//   #MSWP @PLACE(0, -15);
//   #CSP @PLACE(8, -15);
//   #STOPP @PLACE(16, -15);
//   #CVGP @PLACE(24, -15);
//   #VDDA @PLACE(0, 17);
//   #VVCM @PLACE(12, 17);
//   #VAVDD @PLACE(24, 17);
//   #IMAVDD @PLACE(36, 18);
//   #XDUT:VIN @TEXT("${net}", key="netname", size=0.6, halign="end", valign="middle", dx=-0.4, dy=0);
//   #XDUT:PHI_B @TEXT("${net}", key="netname", size=0.6, halign="end", valign="middle", dx=-0.4, dy=0);
//   #XDUT:PHI_BB @TEXT("${net}", key="netname", size=0.6, halign="end", valign="middle", dx=-0.4, dy=0);
//   #XDUT:VG @TEXT("${net}", key="netname", size=0.6, halign="start", valign="middle", dx=0.4, dy=0);
//   #XDUT:AVDD @TEXT("${net}", key="netname", size=0.6, halign="start", valign="middle", rotate=90, dx=0, dy=0.4);
//   %g1 = $GROUND @ATTACH &0 => @PLACE(10, -6.5);
//   &0 @WIRE {#XDUT:VSS %g1:p};
//   #VSRC:1 @TEXT("${net}", key="netname", size=0.6, halign="start", valign="middle", rotate=90, dx=0, dy=0.4);
//   %g2 = $GROUND @ATTACH &0 => @PLACE(-16, 1.5);
//   &0 @WIRE {#VSRC:2 %g2:p};
//   #RS:1 @TEXT("${net}", key="netname", size=0.6, halign="start", valign="middle", rotate=90, dx=0, dy=0.4);
//   #RS:2 @TEXT("${net}", key="netname", size=0.6, halign="end", valign="middle", rotate=90, dx=0, dy=-0.4);
//   #ISMP:P @TEXT("${net}", key="netname", size=0.6, halign="end", valign="middle", dx=-0.4, dy=0);
//   #ISMP:N @TEXT("${net}", key="netname", size=0.6, halign="end", valign="middle", dx=-0.4, dy=0);
//   #ISMP:TRIG @TEXT("${net}", key="netname", size=0.6, halign="end", valign="middle", rotate=90, dx=0, dy=-0.4);
//   %g3 = $GROUND @ATTACH &0 => @PLACE(35, -1.5);
//   &0 @WIRE {#ISMP:VSS %g3:p};
//   #MSWP:1 @TEXT("${net}", key="netname", size=0.6, halign="start", valign="middle", rotate=90, dx=0, dy=0.4);
//   #MSWP:2 @TEXT("${net}", key="netname", size=0.6, halign="end", valign="middle", dx=-0.4, dy=0);
//   #MSWP:3 @TEXT("${net}", key="netname", size=0.6, halign="end", valign="middle", rotate=90, dx=0, dy=-0.4);
//   %g4 = $GROUND @ATTACH &0 => @PLACE(2.5, -15);
//   &0 @WIRE {#MSWP:4 (2.5, -15) (2.5, -15) %g4:p};
//   #CSP:1 @TEXT("${net}", key="netname", size=0.6, halign="start", valign="middle", rotate=90, dx=0, dy=0.4);
//   #CSP:2 @TEXT("${net}", key="netname", size=0.6, halign="end", valign="middle", rotate=90, dx=0, dy=-0.4);
//   #STOPP:1 @TEXT("${net}", key="netname", size=0.6, halign="end", valign="middle", dx=-0.4, dy=0);
//   #STOPP:2 @TEXT("${net}", key="netname", size=0.6, halign="start", valign="middle", dx=0.4, dy=0);
//   #STOPP:3 @TEXT("${net}", key="netname", size=0.6, halign="end", valign="middle", dx=-0.4, dy=0);
//   %g5 = $GROUND @ATTACH &0 => @PLACE(19.5, -18);
//   &0 @WIRE {#STOPP:4 (19.5, -18) (19.5, -18) %g5:p};
//   #CVGP:1 @TEXT("${net}", key="netname", size=0.6, halign="start", valign="middle", rotate=90, dx=0, dy=0.4);
//   %g6 = $GROUND @ATTACH &0 => @PLACE(24, -18.5);
//   &0 @WIRE {#CVGP:2 %g6:p};
//   #VCLK:1 @TEXT("${net}", key="netname", size=0.6, halign="start", valign="middle", rotate=90, dx=0, dy=0.4);
//   %g7 = $GROUND @ATTACH &0 => @PLACE(-16, -16.5);
//   &0 @WIRE {#VCLK:2 %g7:p};
//   #ICG:CLK @TEXT("${net}", key="netname", size=0.6, halign="end", valign="middle", dx=-0.4, dy=0);
//   #ICG:PHI_S @TEXT("${net}", key="netname", size=0.6, halign="start", valign="middle", dx=0.4, dy=0);
//   #ICG:PHI_SB @TEXT("${net}", key="netname", size=0.6, halign="start", valign="middle", dx=0.4, dy=0);
//   #ICG:PHI_B @TEXT("${net}", key="netname", size=0.6, halign="start", valign="middle", dx=0.4, dy=0);
//   #ICG:PHI_BB @TEXT("${net}", key="netname", size=0.6, halign="start", valign="middle", dx=0.4, dy=0);
//   #ICG:CONV @TEXT("${net}", key="netname", size=0.6, halign="start", valign="middle", dx=0.4, dy=0);
//   #ICG:AVDD @TEXT("${net}", key="netname", size=0.6, halign="start", valign="middle", rotate=90, dx=0, dy=0.4);
//   %g8 = $GROUND @ATTACH &0 => @PLACE(34, -25.5);
//   &0 @WIRE {#ICG:VSS %g8:p};
//   #VDDA:1 @TEXT("${net}", key="netname", size=0.6, halign="start", valign="middle", rotate=90, dx=0, dy=0.4);
//   %g9 = $GROUND @ATTACH &0 => @PLACE(0, 13.5);
//   &0 @WIRE {#VDDA:2 %g9:p};
//   #VVCM:1 @TEXT("${net}", key="netname", size=0.6, halign="start", valign="middle", rotate=90, dx=0, dy=0.4);
//   %g10 = $GROUND @ATTACH &0 => @PLACE(12, 13.5);
//   &0 @WIRE {#VVCM:2 %g10:p};
//   #VAVDD:1 @TEXT("${net}", key="netname", size=0.6, halign="start", valign="middle", rotate=90, dx=0, dy=0.4);
//   %g11 = $GROUND @ATTACH &0 => @PLACE(24, 13.5);
//   &0 @WIRE {#VAVDD:2 %g11:p};
//   #IMAVDD:P @TEXT("${net}", key="netname", size=0.6, halign="start", valign="middle", rotate=90, dx=0, dy=0.4);
//   #IMAVDD:N @TEXT("${net}", key="netname", size=0.6, halign="end", valign="middle", rotate=90, dx=0, dy=-0.4);
//   (-30, 31) @TEXT("tb_bootstrap_dc: boosted gate over the input range, edges, current", halign="start") => @SET-STYLE $title_style;
//   (-30, 29.4) @TEXT("VIN steps 0 .. 0.9 V in 0.15 V steps, 4 cycles each, through 50 ohm with the reference switch load", halign="start") => @SET-STYLE $note_style
// }
