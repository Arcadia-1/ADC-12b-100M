// tb_comp_delay: comparator delay, regeneration, reset and energy
// @RNL(type="header") {
//   @VERSION("0.3");
//   @USE-PACKAGE(name="adc28", version="0.1", path="../../design/rnl/adc28.rnl")
// }
// generated by `python -m adcflow gen` from specs/ -- do not edit (tools/adcflow/gen_tb.py)
// Globals vdd, vdd18, tempc, noise_en, devnoise, beh_speed, vref_in come from the run deck.
simulator lang=spectre
parameters cload=10f
parameters tstart=0 tstop=1.45e-08
XDUT (INP INN CLKC OUTP OUTN AVDD 0) adc_comp
VDP (INP 0) vsource type=pwl wave=[0.0000e+00 0.54 3.9000e-10 0.54 4.0000e-10 0.44 7.9000e-10 0.44 8.0000e-10 0.505 1.1900e-09 0.505 1.2000e-09 0.475 1.5900e-09 0.475 1.6000e-09 0.495 1.9900e-09 0.495 2.0000e-09 0.485 2.3900e-09 0.485 2.4000e-09 0.4915 2.7900e-09 0.4915 2.8000e-09 0.4885 3.1900e-09 0.4885 3.2000e-09 0.4905 3.5900e-09 0.4905 3.6000e-09 0.4895 3.9900e-09 0.4895 4.0000e-09 0.49015 4.3900e-09 0.49015 4.4000e-09 0.48985 4.7900e-09 0.48985 4.8000e-09 0.49005 5.1900e-09 0.49005 5.2000e-09 0.48995 5.5900e-09 0.48995 5.6000e-09 0.490015 5.9900e-09 0.490015 6.0000e-09 0.489985 6.3900e-09 0.489985 6.4000e-09 0.490005 6.7900e-09 0.490005 6.8000e-09 0.489995 7.1900e-09 0.489995 7.2000e-09 0.54 7.5900e-09 0.54 7.6000e-09 0.44 7.9900e-09 0.44 8.0000e-09 0.505 8.3900e-09 0.505 8.4000e-09 0.475 8.7900e-09 0.475 8.8000e-09 0.495 9.1900e-09 0.495 9.2000e-09 0.485 9.5900e-09 0.485 9.6000e-09 0.4915 9.9900e-09 0.4915 1.0000e-08 0.4885 1.0390e-08 0.4885 1.0400e-08 0.4905 1.0790e-08 0.4905 1.0800e-08 0.4895 1.1190e-08 0.4895 1.1200e-08 0.49015 1.1590e-08 0.49015 1.1600e-08 0.48985 1.1990e-08 0.48985 1.2000e-08 0.49005 1.2390e-08 0.49005 1.2400e-08 0.48995 1.2790e-08 0.48995 1.2800e-08 0.490015 1.3190e-08 0.490015 1.3200e-08 0.489985 1.3590e-08 0.489985 1.3600e-08 0.490005 1.3990e-08 0.490005 1.4000e-08 0.489995]
VDN (INN 0) vsource type=pwl wave=[0.0000e+00 0.44 3.9000e-10 0.44 4.0000e-10 0.54 7.9000e-10 0.54 8.0000e-10 0.475 1.1900e-09 0.475 1.2000e-09 0.505 1.5900e-09 0.505 1.6000e-09 0.485 1.9900e-09 0.485 2.0000e-09 0.495 2.3900e-09 0.495 2.4000e-09 0.4885 2.7900e-09 0.4885 2.8000e-09 0.4915 3.1900e-09 0.4915 3.2000e-09 0.4895 3.5900e-09 0.4895 3.6000e-09 0.4905 3.9900e-09 0.4905 4.0000e-09 0.48985 4.3900e-09 0.48985 4.4000e-09 0.49015 4.7900e-09 0.49015 4.8000e-09 0.48995 5.1900e-09 0.48995 5.2000e-09 0.49005 5.5900e-09 0.49005 5.6000e-09 0.489985 5.9900e-09 0.489985 6.0000e-09 0.490015 6.3900e-09 0.490015 6.4000e-09 0.489995 6.7900e-09 0.489995 6.8000e-09 0.490005 7.1900e-09 0.490005 7.2000e-09 0.44 7.5900e-09 0.44 7.6000e-09 0.54 7.9900e-09 0.54 8.0000e-09 0.475 8.3900e-09 0.475 8.4000e-09 0.505 8.7900e-09 0.505 8.8000e-09 0.485 9.1900e-09 0.485 9.2000e-09 0.495 9.5900e-09 0.495 9.6000e-09 0.4885 9.9900e-09 0.4885 1.0000e-08 0.4915 1.0390e-08 0.4915 1.0400e-08 0.4895 1.0790e-08 0.4895 1.0800e-08 0.4905 1.1190e-08 0.4905 1.1200e-08 0.48985 1.1590e-08 0.48985 1.1600e-08 0.49015 1.1990e-08 0.49015 1.2000e-08 0.48995 1.2390e-08 0.48995 1.2400e-08 0.49005 1.2790e-08 0.49005 1.2800e-08 0.489985 1.3190e-08 0.489985 1.3200e-08 0.490015 1.3590e-08 0.490015 1.3600e-08 0.489995 1.3990e-08 0.489995 1.4000e-08 0.490005]
VCK (CLKC 0) vsource type=pulse val0=0 val1=vdd period=4e-10 delay=100p width=1.9e-10 rise=10p fall=10p
COP (OUTP 0) capacitor c=cload
CON (OUTN 0) capacitor c=cload
VAVDD (AVDD_S 0) vsource dc=vdd
IMAVDD (AVDD_S AVDD) tb_imeter_va tstart=tstart tstop=tstop label="AVDD" fname="power.txt"
tran1 tran stop=tstop
save INP INN CLKC OUTP OUTN
// @RNL {
//   /* --- semantics --- */
//   &0 @ADD-TO $GROUND_NET_SET;
//   #XDUT @PLACE(7, 0);
//   #VDP @PLACE(-16, 4);
//   #VDN @PLACE(-16, -5);
//   #VCK @PLACE(-16, -14);
//   #COP @PLACE(0, -14);
//   #CON @PLACE(8, -14);
//   #VAVDD @PLACE(0, 16);
//   #IMAVDD @PLACE(12, 18);
//   &INP @WIRE {#XDUT:INP (-2, 1)};
//   (-2.3, 0.75) @TEXT("INP", size=0.6, halign="end");
//   &INN @WIRE {#XDUT:INN (-2, -1)};
//   (-2.3, -1.25) @TEXT("INN", size=0.6, halign="end");
//   &CLKC @WIRE {#XDUT:CLKC (5, -6)};
//   (5.25, -6.3) @TEXT("CLKC", size=0.6, rotate=90, halign="end");
//   &OUTP @WIRE {#XDUT:OUTP (16, 1)};
//   (16.3, 0.75) @TEXT("OUTP", size=0.6, halign="start");
//   &OUTN @WIRE {#XDUT:OUTN (16, -1)};
//   (16.3, -1.25) @TEXT("OUTN", size=0.6, halign="start");
//   &AVDD @WIRE {#XDUT:AVDD (7, 6)};
//   (7.25, 6.3) @TEXT("AVDD", size=0.6, rotate=90, halign="start");
//   %g1 = $GROUND @ATTACH &0 => @PLACE(9, -5.5);
//   &0 @WIRE {#XDUT:VSS %g1:p};
//   &INP @WIRE {#VDP:1 (-16, 8)};
//   (-15.75, 8.3) @TEXT("INP", size=0.6, rotate=90, halign="start");
//   %g2 = $GROUND @ATTACH &0 => @PLACE(-16, 0.5);
//   &0 @WIRE {#VDP:2 %g2:p};
//   &INN @WIRE {#VDN:1 (-16, -1)};
//   (-15.75, -0.7) @TEXT("INN", size=0.6, rotate=90, halign="start");
//   %g3 = $GROUND @ATTACH &0 => @PLACE(-16, -8.5);
//   &0 @WIRE {#VDN:2 %g3:p};
//   &CLKC @WIRE {#VCK:1 (-16, -10)};
//   (-15.75, -9.7) @TEXT("CLKC", size=0.6, rotate=90, halign="start");
//   %g4 = $GROUND @ATTACH &0 => @PLACE(-16, -17.5);
//   &0 @WIRE {#VCK:2 %g4:p};
//   &OUTP @WIRE {#COP:1 (0, -10)};
//   (0.25, -9.7) @TEXT("OUTP", size=0.6, rotate=90, halign="start");
//   %g5 = $GROUND @ATTACH &0 => @PLACE(0, -17.5);
//   &0 @WIRE {#COP:2 %g5:p};
//   &OUTN @WIRE {#CON:1 (8, -10)};
//   (8.25, -9.7) @TEXT("OUTN", size=0.6, rotate=90, halign="start");
//   %g6 = $GROUND @ATTACH &0 => @PLACE(8, -17.5);
//   &0 @WIRE {#CON:2 %g6:p};
//   &AVDD_S @WIRE {#VAVDD:1 (0, 20)};
//   (0.25, 20.3) @TEXT("AVDD_S", size=0.6, rotate=90, halign="start");
//   %g7 = $GROUND @ATTACH &0 => @PLACE(0, 12.5);
//   &0 @WIRE {#VAVDD:2 %g7:p};
//   &AVDD_S @WIRE {#IMAVDD:P (12, 24)};
//   (12.25, 24.3) @TEXT("AVDD_S", size=0.6, rotate=90, halign="start");
//   &AVDD @WIRE {#IMAVDD:N (12, 12)};
//   (12.25, 11.7) @TEXT("AVDD", size=0.6, rotate=90, halign="end");
//   (-30, 30) @TEXT("tb_comp_delay: comparator delay, regeneration, reset and energy", halign="start") => @SET-STYLE $title_style;
//   (-30, 28.4) @TEXT("vd steps through +/-0.1, 0.03, 0.01, 0.003, 0.001, 0.0003, 0.0001, 3e-05, 1e-05 V (twice), CM 0.49 V, one decision per 400 ps", halign="start") => @SET-STYLE $note_style;
//   (-30, 26.8) @TEXT("transient noise off; power.txt gives the AVDD energy", halign="start") => @SET-STYLE $note_style
// }
