// tb_comp_kickback: kickback on floating 1.25 pF inputs, input capacitance
// @RNL(type="header") {
//   @VERSION("0.3");
//   @USE-PACKAGE(name="adc28", version="0.1", path="../../design/rnl/adc28.rnl")
// }
// generated by `python -m adcflow gen` from specs/ -- do not edit (tools/adcflow/gen_tb.py)
// Globals vdd, vdd18, tempc, noise_en, devnoise, beh_speed, vref_in come from the run deck.
simulator lang=spectre
parameters cs=1.25p cload=10f ncyc=8
parameters tstop=ncyc*4e-10+100p
XDUT (INP INN CLKC OUTP OUTN AVDD 0) adc_comp
CSP (INP 0) capacitor c=cs
CSN (INN 0) capacitor c=cs
VCK (CLKC 0) vsource type=pulse val0=0 val1=vdd period=4e-10 delay=100p width=1.9e-10 rise=10p fall=10p
COP (OUTP 0) capacitor c=cload
CON (OUTN 0) capacitor c=cload
// differential input just before every evaluation
ISMP (INP INN CLKC 0) tb_sampler_va vth=vdd/2 dir=1 delay=0 fname="vdiff.txt"
// second instance in reset for the AC input-capacitance measurement
XDUT2 (INP2 INN2 0 OUTP2 OUTN2 AVDD 0) adc_comp
VAC (INP2 0) vsource dc=0.49 mag=1
VIN2 (INN2 0) vsource dc=0.49
VAVDD (AVDD 0) vsource dc=vdd
ic INP=0.4905 INN=0.4895
tran1 tran stop=tstop
ac1 ac freq=100M
save INP INN VAC:p
// @RNL {
//   /* pins connected by net name: the net-name label of rnl-std-fill on every unwired pin, placed below by its key netname */
//   $LABEL_TERMINAL_SET @TEXT("${net}", key="netname", size=0.6);
//   /* --- semantics --- */
//   &0 @ADD-TO $GROUND_NET_SET;
//   #XDUT @PLACE(6, 0);
//   #XDUT2 @PLACE(34, 0);
//   #VCK @PLACE(-16, 5);
//   #VAC @PLACE(-16, -4);
//   #VIN2 @PLACE(-16, -13);
//   #ISMP @PLACE(61, 4);
//   #CSP @PLACE(0, -15);
//   #CSN @PLACE(8, -15);
//   #COP @PLACE(16, -15);
//   #CON @PLACE(24, -15);
//   #VAVDD @PLACE(0, 17);
//   #XDUT:INP @TEXT("${net}", key="netname", size=0.6, halign="end", valign="middle", dx=-0.4, dy=0);
//   #XDUT:INN @TEXT("${net}", key="netname", size=0.6, halign="end", valign="middle", dx=-0.4, dy=0);
//   #XDUT:CLKC @TEXT("${net}", key="netname", size=0.6, halign="end", valign="middle", rotate=90, dx=0, dy=-0.4);
//   #XDUT:OUTP @TEXT("${net}", key="netname", size=0.6, halign="start", valign="middle", dx=0.4, dy=0);
//   #XDUT:OUTN @TEXT("${net}", key="netname", size=0.6, halign="start", valign="middle", dx=0.4, dy=0);
//   #XDUT:AVDD @TEXT("${net}", key="netname", size=0.6, halign="start", valign="middle", rotate=90, dx=0, dy=0.4);
//   %g1 = $GROUND @ATTACH &0 => @PLACE(4, -6.5);
//   &0 @WIRE {#XDUT:VSS %g1:p};
//   #CSP:1 @TEXT("${net}", key="netname", size=0.6, halign="start", valign="middle", rotate=90, dx=0, dy=0.4);
//   %g2 = $GROUND @ATTACH &0 => @PLACE(0, -18.5);
//   &0 @WIRE {#CSP:2 %g2:p};
//   #CSN:1 @TEXT("${net}", key="netname", size=0.6, halign="start", valign="middle", rotate=90, dx=0, dy=0.4);
//   %g3 = $GROUND @ATTACH &0 => @PLACE(8, -18.5);
//   &0 @WIRE {#CSN:2 %g3:p};
//   #VCK:1 @TEXT("${net}", key="netname", size=0.6, halign="start", valign="middle", rotate=90, dx=0, dy=0.4);
//   %g4 = $GROUND @ATTACH &0 => @PLACE(-16, 1.5);
//   &0 @WIRE {#VCK:2 %g4:p};
//   #COP:1 @TEXT("${net}", key="netname", size=0.6, halign="start", valign="middle", rotate=90, dx=0, dy=0.4);
//   %g5 = $GROUND @ATTACH &0 => @PLACE(16, -18.5);
//   &0 @WIRE {#COP:2 %g5:p};
//   #CON:1 @TEXT("${net}", key="netname", size=0.6, halign="start", valign="middle", rotate=90, dx=0, dy=0.4);
//   %g6 = $GROUND @ATTACH &0 => @PLACE(24, -18.5);
//   &0 @WIRE {#CON:2 %g6:p};
//   #ISMP:P @TEXT("${net}", key="netname", size=0.6, halign="end", valign="middle", dx=-0.4, dy=0);
//   #ISMP:N @TEXT("${net}", key="netname", size=0.6, halign="end", valign="middle", dx=-0.4, dy=0);
//   #ISMP:TRIG @TEXT("${net}", key="netname", size=0.6, halign="end", valign="middle", rotate=90, dx=0, dy=-0.4);
//   %g7 = $GROUND @ATTACH &0 => @PLACE(63, -1.5);
//   &0 @WIRE {#ISMP:VSS %g7:p};
//   #XDUT2:INP @TEXT("${net}", key="netname", size=0.6, halign="end", valign="middle", dx=-0.4, dy=0);
//   #XDUT2:INN @TEXT("${net}", key="netname", size=0.6, halign="end", valign="middle", dx=-0.4, dy=0);
//   %g8 = $GROUND @ATTACH &0 => @PLACE(35, -6.5);
//   &0 @WIRE {#XDUT2:CLKC %g8:p};
//   #XDUT2:OUTP @TEXT("${net}", key="netname", size=0.6, halign="start", valign="middle", dx=0.4, dy=0);
//   #XDUT2:OUTN @TEXT("${net}", key="netname", size=0.6, halign="start", valign="middle", dx=0.4, dy=0);
//   #XDUT2:AVDD @TEXT("${net}", key="netname", size=0.6, halign="start", valign="middle", rotate=90, dx=0, dy=0.4);
//   %g9 = $GROUND @ATTACH &0 => @PLACE(32, -6.5);
//   &0 @WIRE {#XDUT2:VSS %g9:p};
//   #VAC:1 @TEXT("${net}", key="netname", size=0.6, halign="start", valign="middle", rotate=90, dx=0, dy=0.4);
//   %g10 = $GROUND @ATTACH &0 => @PLACE(-16, -7.5);
//   &0 @WIRE {#VAC:2 %g10:p};
//   #VIN2:1 @TEXT("${net}", key="netname", size=0.6, halign="start", valign="middle", rotate=90, dx=0, dy=0.4);
//   %g11 = $GROUND @ATTACH &0 => @PLACE(-16, -16.5);
//   &0 @WIRE {#VIN2:2 %g11:p};
//   #VAVDD:1 @TEXT("${net}", key="netname", size=0.6, halign="start", valign="middle", rotate=90, dx=0, dy=0.4);
//   %g12 = $GROUND @ATTACH &0 => @PLACE(0, 13.5);
//   &0 @WIRE {#VAVDD:2 %g12:p};
//   (-30, 31) @TEXT("tb_comp_kickback: kickback on floating 1.25 pF inputs, input capacitance", halign="start") => @SET-STYLE $title_style;
//   (-30, 29.4) @TEXT("inputs preset to 0.49 V +/- 0.5 mV and left floating on cs; the change of V(INP)-V(INN) per cycle is the kickback", halign="start") => @SET-STYLE $note_style;
//   (-30, 27.8) @TEXT("XDUT2 (CLKC = 0) with an AC source on INP2: C_in = Im(I)/(2 pi f) at 100 MHz", halign="start") => @SET-STYLE $note_style
// }
