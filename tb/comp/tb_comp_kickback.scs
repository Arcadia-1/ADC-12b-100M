// tb_comp_kickback: kickback on floating 1.25 pF inputs, input capacitance
// @RNL(type="header") {
//   @VERSION("0.3");
//   @USE-PACKAGE(name="adc28", version="0.1", path="../../design/rnl/adc28.rnl")
// }
// generated by `python -m adcflow gen` from specs/ -- do not edit (tools/adcflow/gen_tb.py)
// Globals vdd, vdd18, tempc, noise_en, devnoise, beh_speed, vref_in come from the run deck.
simulator lang=spectre
parameters cs=1.25p cload=10f ncyc=8
parameters tstop=ncyc*4e-10+100p
XDUT (INP INN CLKC OUTP OUTN AVDD 0) adc_comp
CSP (INP 0) capacitor c=cs
CSN (INN 0) capacitor c=cs
VCK (CLKC 0) vsource type=pulse val0=0 val1=vdd period=4e-10 delay=100p width=1.9e-10 rise=10p fall=10p
COP (OUTP 0) capacitor c=cload
CON (OUTN 0) capacitor c=cload
// differential input just before every evaluation
ISMP (INP INN CLKC 0) tb_sampler_va vth=vdd/2 dir=1 delay=0 fname="vdiff.txt"
// second instance in reset for the AC input-capacitance measurement
XDUT2 (INP2 INN2 0 OUTP2 OUTN2 AVDD 0) adc_comp
VAC (INP2 0) vsource dc=0.49 mag=1
VIN2 (INN2 0) vsource dc=0.49
VAVDD (AVDD 0) vsource dc=vdd
ic INP=0.4905 INN=0.4895
tran1 tran stop=tstop
ac1 ac freq=100M
save INP INN VAC:p
// @RNL {
//   /* --- semantics --- */
//   &0 @ADD-TO $GROUND_NET_SET;
//   #XDUT @PLACE(7, 0);
//   #XDUT2 @PLACE(37, 0);
//   #VCK @PLACE(-16, 4);
//   #VAC @PLACE(-16, -5);
//   #VIN2 @PLACE(-16, -14);
//   #ISMP @PLACE(67, 3);
//   #CSP @PLACE(0, -14);
//   #CSN @PLACE(8, -14);
//   #COP @PLACE(16, -14);
//   #CON @PLACE(24, -14);
//   #VAVDD @PLACE(0, 16);
//   &INP @WIRE {#XDUT:INP (-2, 1)};
//   (-2.3, 0.75) @TEXT("INP", size=0.6, halign="end");
//   &INN @WIRE {#XDUT:INN (-2, -1)};
//   (-2.3, -1.25) @TEXT("INN", size=0.6, halign="end");
//   &CLKC @WIRE {#XDUT:CLKC (5, -6)};
//   (5.25, -6.3) @TEXT("CLKC", size=0.6, rotate=90, halign="end");
//   &OUTP @WIRE {#XDUT:OUTP (16, 1)};
//   (16.3, 0.75) @TEXT("OUTP", size=0.6, halign="start");
//   &OUTN @WIRE {#XDUT:OUTN (16, -1)};
//   (16.3, -1.25) @TEXT("OUTN", size=0.6, halign="start");
//   &AVDD @WIRE {#XDUT:AVDD (7, 6)};
//   (7.25, 6.3) @TEXT("AVDD", size=0.6, rotate=90, halign="start");
//   %g1 = $GROUND @ATTACH &0 => @PLACE(9, -5.5);
//   &0 @WIRE {#XDUT:VSS %g1:p};
//   &INP @WIRE {#CSP:1 (0, -10)};
//   (0.25, -9.7) @TEXT("INP", size=0.6, rotate=90, halign="start");
//   %g2 = $GROUND @ATTACH &0 => @PLACE(0, -17.5);
//   &0 @WIRE {#CSP:2 %g2:p};
//   &INN @WIRE {#CSN:1 (8, -10)};
//   (8.25, -9.7) @TEXT("INN", size=0.6, rotate=90, halign="start");
//   %g3 = $GROUND @ATTACH &0 => @PLACE(8, -17.5);
//   &0 @WIRE {#CSN:2 %g3:p};
//   &CLKC @WIRE {#VCK:1 (-16, 8)};
//   (-15.75, 8.3) @TEXT("CLKC", size=0.6, rotate=90, halign="start");
//   %g4 = $GROUND @ATTACH &0 => @PLACE(-16, 0.5);
//   &0 @WIRE {#VCK:2 %g4:p};
//   &OUTP @WIRE {#COP:1 (16, -10)};
//   (16.25, -9.7) @TEXT("OUTP", size=0.6, rotate=90, halign="start");
//   %g5 = $GROUND @ATTACH &0 => @PLACE(16, -17.5);
//   &0 @WIRE {#COP:2 %g5:p};
//   &OUTN @WIRE {#CON:1 (24, -10)};
//   (24.25, -9.7) @TEXT("OUTN", size=0.6, rotate=90, halign="start");
//   %g6 = $GROUND @ATTACH &0 => @PLACE(24, -17.5);
//   &0 @WIRE {#CON:2 %g6:p};
//   &INP @WIRE {#ISMP:P (58, 4)};
//   (57.7, 3.75) @TEXT("INP", size=0.6, halign="end");
//   &INN @WIRE {#ISMP:N (58, 2)};
//   (57.7, 1.75) @TEXT("INN", size=0.6, halign="end");
//   &CLKC @WIRE {#ISMP:TRIG (65, -3)};
//   (65.25, -3.3) @TEXT("CLKC", size=0.6, rotate=90, halign="end");
//   %g7 = $GROUND @ATTACH &0 => @PLACE(69, -2.5);
//   &0 @WIRE {#ISMP:VSS %g7:p};
//   &INP2 @WIRE {#XDUT2:INP (28, 1)};
//   (27.7, 0.75) @TEXT("INP2", size=0.6, halign="end");
//   &INN2 @WIRE {#XDUT2:INN (28, -1)};
//   (27.7, -1.25) @TEXT("INN2", size=0.6, halign="end");
//   %g8 = $GROUND @ATTACH &0 => @PLACE(35, -5.5);
//   &0 @WIRE {#XDUT2:CLKC %g8:p};
//   &OUTP2 @WIRE {#XDUT2:OUTP (46, 1)};
//   (46.3, 0.75) @TEXT("OUTP2", size=0.6, halign="start");
//   &OUTN2 @WIRE {#XDUT2:OUTN (46, -1)};
//   (46.3, -1.25) @TEXT("OUTN2", size=0.6, halign="start");
//   &AVDD @WIRE {#XDUT2:AVDD (37, 6)};
//   (37.25, 6.3) @TEXT("AVDD", size=0.6, rotate=90, halign="start");
//   %g9 = $GROUND @ATTACH &0 => @PLACE(39, -5.5);
//   &0 @WIRE {#XDUT2:VSS %g9:p};
//   &INP2 @WIRE {#VAC:1 (-16, -1)};
//   (-15.75, -0.7) @TEXT("INP2", size=0.6, rotate=90, halign="start");
//   %g10 = $GROUND @ATTACH &0 => @PLACE(-16, -8.5);
//   &0 @WIRE {#VAC:2 %g10:p};
//   &INN2 @WIRE {#VIN2:1 (-16, -10)};
//   (-15.75, -9.7) @TEXT("INN2", size=0.6, rotate=90, halign="start");
//   %g11 = $GROUND @ATTACH &0 => @PLACE(-16, -17.5);
//   &0 @WIRE {#VIN2:2 %g11:p};
//   &AVDD @WIRE {#VAVDD:1 (0, 20)};
//   (0.25, 20.3) @TEXT("AVDD", size=0.6, rotate=90, halign="start");
//   %g12 = $GROUND @ATTACH &0 => @PLACE(0, 12.5);
//   &0 @WIRE {#VAVDD:2 %g12:p};
//   (-30, 30) @TEXT("tb_comp_kickback: kickback on floating 1.25 pF inputs, input capacitance", halign="start") => @SET-STYLE $title_style;
//   (-30, 28.4) @TEXT("inputs preset to 0.49 V +/- 0.5 mV and left floating on cs; the change of V(INP)-V(INN) per cycle is the kickback", halign="start") => @SET-STYLE $note_style;
//   (-30, 26.8) @TEXT("XDUT2 (CLKC = 0) with an AC source on INP2: C_in = Im(I)/(2 pi f) at 100 MHz", halign="start") => @SET-STYLE $note_style
// }
