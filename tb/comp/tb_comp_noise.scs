// tb_comp_noise: input-referred noise and offset from P(OUTP) vs vd
// @RNL(type="header") {
//   @VERSION("0.3");
//   @USE-PACKAGE(name="adc28", version="0.1", path="../../design/rnl/adc28.rnl")
// }
// generated by `python -m adcflow gen` from specs/ -- do not edit (tools/adcflow/gen_tb.py)
// Globals vdd, vdd18, tempc, noise_en, devnoise, beh_speed, vref_in come from the run deck.
simulator lang=spectre
parameters cload=10f nfmax=50G
parameters tstop=3.329e-07
XDUT (INP INN CLKC OUTP OUTN AVDD 0) adc_comp
VDP (INP 0) vsource type=pwl wave=[0.0000e+00 0.48985 2.5590e-08 0.48985 2.5600e-08 0.489875 5.1190e-08 0.489875 5.1200e-08 0.4899 7.6790e-08 0.4899 7.6800e-08 0.489925 1.0239e-07 0.489925 1.0240e-07 0.48995 1.2799e-07 0.48995 1.2800e-07 0.489975 1.5359e-07 0.489975 1.5360e-07 0.49 1.7919e-07 0.49 1.7920e-07 0.490025 2.0479e-07 0.490025 2.0480e-07 0.49005 2.3039e-07 0.49005 2.3040e-07 0.490075 2.5599e-07 0.490075 2.5600e-07 0.4901 2.8159e-07 0.4901 2.8160e-07 0.490125 3.0719e-07 0.490125 3.0720e-07 0.49015]
VDN (INN 0) vsource type=pwl wave=[0.0000e+00 0.49015 2.5590e-08 0.49015 2.5600e-08 0.490125 5.1190e-08 0.490125 5.1200e-08 0.4901 7.6790e-08 0.4901 7.6800e-08 0.490075 1.0239e-07 0.490075 1.0240e-07 0.49005 1.2799e-07 0.49005 1.2800e-07 0.490025 1.5359e-07 0.490025 1.5360e-07 0.49 1.7919e-07 0.49 1.7920e-07 0.489975 2.0479e-07 0.489975 2.0480e-07 0.48995 2.3039e-07 0.48995 2.3040e-07 0.489925 2.5599e-07 0.489925 2.5600e-07 0.4899 2.8159e-07 0.4899 2.8160e-07 0.489875 3.0719e-07 0.489875 3.0720e-07 0.48985]
VCK (CLKC 0) vsource type=pulse val0=0 val1=vdd period=4e-10 delay=100p width=1.9e-10 rise=10p fall=10p
COP (OUTP 0) capacitor c=cload
CON (OUTN 0) capacitor c=cload
// decision of every cycle, sampled when CLKC falls
ISMP (OUTP OUTN CLKC 0) tb_sampler_va vth=vdd/2 dir=-1 delay=0 fname="decisions.txt"
VAVDD (AVDD 0) vsource dc=vdd
tran1 tran stop=tstop noisefmax=nfmax*noise_en*devnoise noiseseed=1 outputstart=tstop
tbopts options save=none
// @RNL {
//   /* --- semantics --- */
//   &0 @ADD-TO $GROUND_NET_SET;
//   #XDUT @PLACE(7, 0);
//   #VDP @PLACE(-16, 4);
//   #VDN @PLACE(-16, -5);
//   #VCK @PLACE(-16, -14);
//   #ISMP @PLACE(37, 3);
//   #COP @PLACE(0, -14);
//   #CON @PLACE(8, -14);
//   #VAVDD @PLACE(0, 16);
//   &INP @WIRE {#XDUT:INP (-2, 1)};
//   (-2.3, 0.75) @TEXT("INP", size=0.6, halign="end");
//   &INN @WIRE {#XDUT:INN (-2, -1)};
//   (-2.3, -1.25) @TEXT("INN", size=0.6, halign="end");
//   &CLKC @WIRE {#XDUT:CLKC (5, -6)};
//   (5.25, -6.3) @TEXT("CLKC", size=0.6, rotate=90, halign="end");
//   &OUTP @WIRE {#XDUT:OUTP (16, 1)};
//   (16.3, 0.75) @TEXT("OUTP", size=0.6, halign="start");
//   &OUTN @WIRE {#XDUT:OUTN (16, -1)};
//   (16.3, -1.25) @TEXT("OUTN", size=0.6, halign="start");
//   &AVDD @WIRE {#XDUT:AVDD (7, 6)};
//   (7.25, 6.3) @TEXT("AVDD", size=0.6, rotate=90, halign="start");
//   %g1 = $GROUND @ATTACH &0 => @PLACE(9, -5.5);
//   &0 @WIRE {#XDUT:VSS %g1:p};
//   &INP @WIRE {#VDP:1 (-16, 8)};
//   (-15.75, 8.3) @TEXT("INP", size=0.6, rotate=90, halign="start");
//   %g2 = $GROUND @ATTACH &0 => @PLACE(-16, 0.5);
//   &0 @WIRE {#VDP:2 %g2:p};
//   &INN @WIRE {#VDN:1 (-16, -1)};
//   (-15.75, -0.7) @TEXT("INN", size=0.6, rotate=90, halign="start");
//   %g3 = $GROUND @ATTACH &0 => @PLACE(-16, -8.5);
//   &0 @WIRE {#VDN:2 %g3:p};
//   &CLKC @WIRE {#VCK:1 (-16, -10)};
//   (-15.75, -9.7) @TEXT("CLKC", size=0.6, rotate=90, halign="start");
//   %g4 = $GROUND @ATTACH &0 => @PLACE(-16, -17.5);
//   &0 @WIRE {#VCK:2 %g4:p};
//   &OUTP @WIRE {#COP:1 (0, -10)};
//   (0.25, -9.7) @TEXT("OUTP", size=0.6, rotate=90, halign="start");
//   %g5 = $GROUND @ATTACH &0 => @PLACE(0, -17.5);
//   &0 @WIRE {#COP:2 %g5:p};
//   &OUTN @WIRE {#CON:1 (8, -10)};
//   (8.25, -9.7) @TEXT("OUTN", size=0.6, rotate=90, halign="start");
//   %g6 = $GROUND @ATTACH &0 => @PLACE(8, -17.5);
//   &0 @WIRE {#CON:2 %g6:p};
//   &OUTP @WIRE {#ISMP:P (28, 4)};
//   (27.7, 3.75) @TEXT("OUTP", size=0.6, halign="end");
//   &OUTN @WIRE {#ISMP:N (28, 2)};
//   (27.7, 1.75) @TEXT("OUTN", size=0.6, halign="end");
//   &CLKC @WIRE {#ISMP:TRIG (35, -3)};
//   (35.25, -3.3) @TEXT("CLKC", size=0.6, rotate=90, halign="end");
//   %g7 = $GROUND @ATTACH &0 => @PLACE(39, -2.5);
//   &0 @WIRE {#ISMP:VSS %g7:p};
//   &AVDD @WIRE {#VAVDD:1 (0, 20)};
//   (0.25, 20.3) @TEXT("AVDD", size=0.6, rotate=90, halign="start");
//   %g8 = $GROUND @ATTACH &0 => @PLACE(0, 12.5);
//   &0 @WIRE {#VAVDD:2 %g8:p};
//   (-30, 30) @TEXT("tb_comp_noise: input-referred noise and offset from P(OUTP) vs vd", halign="start") => @SET-STYLE $title_style;
//   (-30, 28.4) @TEXT("13 levels of vd from -300 to 300 uV, 64 decisions each", halign="start") => @SET-STYLE $note_style;
//   (-30, 26.8) @TEXT("Gaussian CDF fit gives sigma (noise) and mean (offset)", halign="start") => @SET-STYLE $note_style
// }
